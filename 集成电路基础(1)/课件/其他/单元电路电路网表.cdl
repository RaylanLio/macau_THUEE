* $Id: smic18.cdl,v 1.4 2003-03-05 13:42:29-08 phuoc Exp $
*.SCALE meter
.GLOBAL GND VSS VDD

.subckt ADDFHX1 CO S A B CI
M0 net105 net123 net132 VDD P l=0.18u w=0.72u
M1 net105 net117 net130 VDD P l=0.18u w=0.72u
M2 net111 net123 net130 VDD P l=0.18u w=0.72u
M3 net111 net117 net124 VDD P l=0.18u w=0.72u
M4 net117 net132 net136 VDD P l=0.18u w=1.14u
M5 net117 B net138 VDD P l=0.18u w=1.14u
M6 net123 net132 net138 VDD P l=0.18u w=1.14u
M7 net123 B net136 VDD P l=0.18u w=1.14u
M8 net105 net117 net132 VSS N l=0.18u w=0.48u
M9 net105 net123 net130 VSS N l=0.18u w=0.48u
M10 net111 net117 net130 VSS N l=0.18u w=0.48u
M11 net111 net123 net124 VSS N l=0.18u w=0.48u
M12 net117 B net136 VSS N l=0.18u w=0.76u
M13 net117 net132 net138 VSS N l=0.18u w=0.76u
M14 net123 B net138 VSS N l=0.18u w=0.76u
M15 net123 net132 net136 VSS N l=0.18u w=0.76u
M16 net124 net130 VSS VSS N l=0.18u w=0.48u
M17 VDD net130 net124 VDD P l=0.18u w=0.72u
M18 CO net105 VSS VSS N l=0.18u w=0.6u
M19 VDD net105 CO VDD P l=0.18u w=0.9u
M20 S net111 VSS VSS N l=0.18u w=0.6u
M21 VDD net111 S VDD P l=0.18u w=0.9u
M22 net130 CI VSS VSS N l=0.18u w=0.66u
M23 VDD CI net130 VDD P l=0.18u w=1u
M24 net132 B VSS VSS N l=0.18u w=1.08u
M25 VDD B net132 VDD P l=0.18u w=1.62u
M26 net134 A VSS VSS N l=0.18u w=0.3u
M27 VDD A net134 VDD P l=0.18u w=0.46u
M28 net136 net134 VSS VSS N l=0.18u w=0.76u
M29 VDD net134 net136 VDD P l=0.18u w=1.14u
M30 net138 A VSS VSS N l=0.18u w=0.76u
M31 VDD A net138 VDD P l=0.18u w=1.14u
.ends ADDFHX1
*.SCALE meter
.GLOBAL GND VSS VDD

.subckt ADDFHX2 CO S A B CI
M0 net76 net82 VSS VSS N l=0.18u w=0.96u
M1 VDD net82 net76 VDD P l=0.18u w=1.44u
M2 CO net119 VSS VSS N l=0.18u w=1.2u
M3 VDD net119 CO VDD P l=0.18u w=1.76u
M4 S net125 VSS VSS N l=0.18u w=1.2u
M5 VDD net125 S VDD P l=0.18u w=1.76u
M6 net82 CI VSS VSS N l=0.18u w=1.36u
M7 VDD CI net82 VDD P l=0.18u w=2u
M8 net84 B VSS VSS N l=0.18u w=2.16u
M9 VDD B net84 VDD P l=0.18u w=3.24u
M10 net86 A VSS VSS N l=0.18u w=0.6u
M11 VDD A net86 VDD P l=0.18u w=0.9u
M12 net88 net86 VSS VSS N l=0.18u w=1.52u
M13 VDD net86 net88 VDD P l=0.18u w=2.28u
M14 net119 net137 net84 VDD P l=0.18u w=1.36u
M15 net119 net131 net82 VDD P l=0.18u w=1.4u
M16 net125 net137 net82 VDD P l=0.18u w=1.44u
M17 net125 net131 net76 VDD P l=0.18u w=1.44u
M18 net131 net84 net88 VDD P l=0.18u w=2.28u
M19 net131 B net138 VDD P l=0.18u w=2.28u
M20 net137 net84 net138 VDD P l=0.18u w=2.28u
M21 net137 B net88 VDD P l=0.18u w=2.28u
M22 net119 net131 net84 VSS N l=0.18u w=0.96u
M23 net119 net137 net82 VSS N l=0.18u w=0.92u
M24 net125 net131 net82 VSS N l=0.18u w=0.94u
M25 net125 net137 net76 VSS N l=0.18u w=0.96u
M26 net131 B net88 VSS N l=0.18u w=1.52u
M27 net131 net84 net138 VSS N l=0.18u w=1.52u
M28 net137 B net138 VSS N l=0.18u w=1.36u
M29 net137 net84 net88 VSS N l=0.18u w=1.52u
M30 net138 A VSS VSS N l=0.19u w=1.41u
M31 VDD A net138 VDD P l=0.18u w=2.1u
.ends ADDFHX2
*.SCALE meter
.GLOBAL GND VSS VDD

.subckt ADDFHX4 CO S A B CI
M0 net76 net82 VSS VSS N l=0.18u w=0.96u
M1 VDD net82 net76 VDD P l=0.18u w=1.44u
M2 CO net119 VSS VSS N l=0.18u w=2.4u
M3 VDD net119 CO VDD P l=0.18u w=3.6u
M4 S net125 VSS VSS N l=0.18u w=2.4u
M5 VDD net125 S VDD P l=0.18u w=3.6u
M6 net82 CI VSS VSS N l=0.18u w=1.36u
M7 VDD CI net82 VDD P l=0.18u w=2u
M8 net84 B VSS VSS N l=0.18u w=2.16u
M9 VDD B net84 VDD P l=0.18u w=3.24u
M10 net86 A VSS VSS N l=0.18u w=0.6u
M11 VDD A net86 VDD P l=0.18u w=0.9u
M12 net88 net86 VSS VSS N l=0.18u w=1.52u
M13 VDD net86 net88 VDD P l=0.18u w=2.28u
M14 net119 net137 net84 VDD P l=0.18u w=1.36u
M15 net119 net131 net82 VDD P l=0.18u w=1.4u
M16 net125 net137 net82 VDD P l=0.18u w=1.44u
M17 net125 net131 net76 VDD P l=0.18u w=1.44u
M18 net131 net84 net88 VDD P l=0.18u w=2.28u
M19 net131 B net138 VDD P l=0.18u w=2.28u
M20 net137 net84 net138 VDD P l=0.18u w=2.28u
M21 net137 B net88 VDD P l=0.18u w=2.28u
M22 net119 net131 net84 VSS N l=0.18u w=0.96u
M23 net119 net137 net82 VSS N l=0.18u w=0.92u
M24 net125 net131 net82 VSS N l=0.18u w=0.94u
M25 net125 net137 net76 VSS N l=0.18u w=0.96u
M26 net131 B net88 VSS N l=0.18u w=1.52u
M27 net131 net84 net138 VSS N l=0.18u w=1.52u
M28 net137 B net138 VSS N l=0.18u w=1.36u
M29 net137 net84 net88 VSS N l=0.18u w=1.52u
M30 net138 A VSS VSS N l=0.19u w=1.41u
M31 VDD A net138 VDD P l=0.18u w=2.1u
.ends ADDFHX4
*.SCALE meter
.GLOBAL GND VSS VDD

.subckt ADDFHXL CO S A B CI
M0 net105 net123 net132 VDD P l=0.18u w=0.84u
M1 net105 net117 net130 VDD P l=0.18u w=0.84u
M2 net111 net123 net130 VDD P l=0.18u w=0.84u
M3 net111 net117 net124 VDD P l=0.18u w=0.84u
M4 net117 net132 net136 VDD P l=0.18u w=0.84u
M5 net117 B net138 VDD P l=0.18u w=0.84u
M6 net123 net132 net138 VDD P l=0.18u w=0.84u
M7 net123 B net136 VDD P l=0.18u w=0.84u
M8 net105 net117 net132 VSS N l=0.18u w=0.56u
M9 net105 net123 net130 VSS N l=0.18u w=0.56u
M10 net111 net117 net130 VSS N l=0.18u w=0.56u
M11 net111 net123 net124 VSS N l=0.18u w=0.56u
M12 net117 B net136 VSS N l=0.18u w=0.56u
M13 net117 net132 net138 VSS N l=0.18u w=0.56u
M14 net123 B net138 VSS N l=0.18u w=0.56u
M15 net123 net132 net136 VSS N l=0.18u w=0.56u
M16 net124 net130 VSS VSS N l=0.18u w=0.3u
M17 VDD net130 net124 VDD P l=0.18u w=0.42u
M18 CO net105 VSS VSS N l=0.18u w=0.42u
M19 VDD net105 CO VDD P l=0.18u w=0.64u
M20 S net111 VSS VSS N l=0.18u w=0.42u
M21 VDD net111 S VDD P l=0.18u w=0.64u
M22 net130 CI VSS VSS N l=0.18u w=0.3u
M23 VDD CI net130 VDD P l=0.18u w=0.42u
M24 net132 B VSS VSS N l=0.18u w=0.3u
M25 VDD B net132 VDD P l=0.18u w=0.42u
M26 net134 A VSS VSS N l=0.18u w=0.3u
M27 VDD A net134 VDD P l=0.18u w=0.42u
M28 net136 net134 VSS VSS N l=0.18u w=0.3u
M29 VDD net134 net136 VDD P l=0.18u w=0.42u
M30 net138 A VSS VSS N l=0.18u w=0.3u
M31 VDD A net138 VDD P l=0.18u w=0.42u
.ends ADDFHXL
*.SCALE meter
.GLOBAL GND VSS VDD

.subckt ADDFX1 CO S A B CI
M0 xo net117 net119 VDD P l=0.18u w=0.64u
M1 xn net109 net119 VDD P l=0.18u w=0.64u
M2 xn net119 net109 VDD P l=0.18u w=0.96u
M3 xo net119 net117 VDD P l=0.18u w=0.96u
M4 net115 xn net78 VDD P l=0.18u w=0.64u
M5 net78 xo net117 VDD P l=0.18u w=0.64u
M6 net108 CI xn VDD P l=0.18u w=0.64u
M7 net108 net115 xo VDD P l=0.18u w=0.64u
M8 xo net109 net119 VSS N l=0.18u w=0.42u
M9 xn net117 net119 VSS N l=0.18u w=0.42u
M10 xo net119 net109 VSS N l=0.18u w=0.64u
M11 xn net119 net117 VSS N l=0.18u w=0.64u
M12 net115 xo net78 VSS N l=0.18u w=0.42u
M13 net78 xn net117 VSS N l=0.18u w=0.42u
M14 net108 net115 xn VSS N l=0.18u w=0.42u
M15 net108 CI xo VSS N l=0.18u w=0.42u
M16 net109 net117 VSS VSS N l=0.18u w=0.84u
M17 VDD net117 net109 VDD P l=0.18u w=1.26u
M18 S net108 VSS VSS N l=0.18u w=0.6u
M19 VDD net108 S VDD P l=0.18u w=0.9u
M20 CO net78 VSS VSS N l=0.18u w=0.6u
M21 VDD net78 CO VDD P l=0.18u w=0.9u
M22 net115 CI VSS VSS N l=0.18u w=0.42u
M23 VDD CI net115 VDD P l=0.18u w=0.64u
M24 net117 B VSS VSS N l=0.18u w=1.2u
M25 VDD B net117 VDD P l=0.18u w=1.79u
M26 net119 A VSS VSS N l=0.18u w=1.2u
M27 VDD A net119 VDD P l=0.18u w=1.8u
.ends ADDFX1
*.SCALE meter
.GLOBAL GND VSS VDD

.subckt ADDFX2 CO S A B CI
M0 xo net117 net119 VDD P l=0.18u w=0.64u
M1 xn net109 net119 VDD P l=0.18u w=0.64u
M2 xn net119 net109 VDD P l=0.18u w=0.96u
M3 xo net119 net117 VDD P l=0.18u w=0.96u
M4 net115 xn net78 VDD P l=0.18u w=0.64u
M5 net78 xo net117 VDD P l=0.18u w=0.64u
M6 net108 CI xn VDD P l=0.18u w=0.64u
M7 net108 net115 xo VDD P l=0.18u w=0.64u
M8 xo net109 net119 VSS N l=0.18u w=0.42u
M9 xn net117 net119 VSS N l=0.18u w=0.42u
M10 xo net119 net109 VSS N l=0.18u w=0.64u
M11 xn net119 net117 VSS N l=0.18u w=0.64u
M12 net115 xo net78 VSS N l=0.18u w=0.42u
M13 net78 xn net117 VSS N l=0.18u w=0.42u
M14 net108 net115 xn VSS N l=0.18u w=0.42u
M15 net108 CI xo VSS N l=0.18u w=0.42u
M16 net109 net117 VSS VSS N l=0.18u w=0.84u
M17 VDD net117 net109 VDD P l=0.18u w=1.26u
M18 S net108 VSS VSS N l=0.18u w=1.18u
M19 VDD net108 S VDD P l=0.18u w=1.78u
M20 CO net78 VSS VSS N l=0.18u w=1.18u
M21 VDD net78 CO VDD P l=0.18u w=1.78u
M22 net115 CI VSS VSS N l=0.18u w=0.42u
M23 VDD CI net115 VDD P l=0.18u w=0.64u
M24 net117 B VSS VSS N l=0.18u w=1.2u
M25 VDD B net117 VDD P l=0.18u w=1.79u
M26 net119 A VSS VSS N l=0.18u w=1.2u
M27 VDD A net119 VDD P l=0.18u w=1.8u
.ends ADDFX2
*.SCALE meter
.GLOBAL GND VSS VDD

.subckt ADDFX4 CO S A B CI
M0 xo net117 net119 VDD P l=0.18u w=0.64u
M1 xn net109 net119 VDD P l=0.18u w=0.64u
M2 xn net119 net109 VDD P l=0.18u w=0.96u
M3 xo net119 net117 VDD P l=0.18u w=0.96u
M4 net115 xn net78 VDD P l=0.18u w=0.64u
M5 net78 xo net117 VDD P l=0.18u w=0.64u
M6 net108 CI xn VDD P l=0.18u w=0.64u
M7 net108 net115 xo VDD P l=0.18u w=0.64u
M8 xo net109 net119 VSS N l=0.18u w=0.42u
M9 xn net117 net119 VSS N l=0.18u w=0.42u
M10 xo net119 net109 VSS N l=0.18u w=0.64u
M11 xn net119 net117 VSS N l=0.18u w=0.64u
M12 net115 xo net78 VSS N l=0.18u w=0.42u
M13 net78 xn net117 VSS N l=0.18u w=0.42u
M14 net108 net115 xn VSS N l=0.18u w=0.42u
M15 net108 CI xo VSS N l=0.18u w=0.42u
M16 net109 net117 VSS VSS N l=0.18u w=0.84u
M17 VDD net117 net109 VDD P l=0.18u w=1.26u
M18 S net108 VSS VSS N l=0.18u w=2.4u
M19 VDD net108 S VDD P l=0.18u w=3.6u
M20 CO net78 VSS VSS N l=0.18u w=2.4u
M21 VDD net78 CO VDD P l=0.18u w=3.6u
M22 net115 CI VSS VSS N l=0.18u w=0.42u
M23 VDD CI net115 VDD P l=0.18u w=0.64u
M24 net117 B VSS VSS N l=0.18u w=1.2u
M25 VDD B net117 VDD P l=0.18u w=1.79u
M26 net119 A VSS VSS N l=0.18u w=1.2u
M27 VDD A net119 VDD P l=0.18u w=1.8u
.ends ADDFX4
*.SCALE meter
.GLOBAL GND VSS VDD

.subckt ADDFXL CO S A B CI
M0 xo net117 net119 VDD P l=0.18u w=0.64u
M1 xn net109 net119 VDD P l=0.18u w=0.64u
M2 xn net119 net109 VDD P l=0.18u w=0.96u
M3 xo net119 net117 VDD P l=0.18u w=0.96u
M4 net115 xn net78 VDD P l=0.18u w=0.64u
M5 net78 xo net117 VDD P l=0.18u w=0.64u
M6 net108 CI xn VDD P l=0.18u w=0.64u
M7 net108 net115 xo VDD P l=0.18u w=0.64u
M8 xo net109 net119 VSS N l=0.18u w=0.42u
M9 xn net117 net119 VSS N l=0.18u w=0.42u
M10 xo net119 net109 VSS N l=0.18u w=0.64u
M11 xn net119 net117 VSS N l=0.18u w=0.64u
M12 net115 xo net78 VSS N l=0.18u w=0.42u
M13 net78 xn net117 VSS N l=0.18u w=0.42u
M14 net108 net115 xn VSS N l=0.18u w=0.42u
M15 net108 CI xo VSS N l=0.18u w=0.42u
M16 net109 net117 VSS VSS N l=0.18u w=0.84u
M17 VDD net117 net109 VDD P l=0.18u w=1.26u
M18 S net108 VSS VSS N l=0.18u w=0.6u
M19 VDD net108 S VDD P l=0.18u w=0.9u
M20 CO net78 VSS VSS N l=0.18u w=0.6u
M21 VDD net78 CO VDD P l=0.18u w=0.9u
M22 net115 CI VSS VSS N l=0.18u w=0.42u
M23 VDD CI net115 VDD P l=0.18u w=0.64u
M24 net117 B VSS VSS N l=0.18u w=1.2u
M25 VDD B net117 VDD P l=0.18u w=1.79u
M26 net119 A VSS VSS N l=0.18u w=1.2u
M27 VDD A net119 VDD P l=0.18u w=1.8u
.ends ADDFXL
*.SCALE meter
.GLOBAL GND VSS VDD

.subckt ADDHX1 CO S A B
M0 VDD A net27 VDD P l=0.18u w=0.36u
M1 VDD B net27 VDD P l=0.18u w=0.36u
M2 hnet15 A VSS VSS N l=0.18u w=0.32u
M3 net27 B hnet15 VSS N l=0.18u w=0.32u
M4 S B net45 VDD P l=0.18u w=1.74u
M5 S net35 net46 VDD P l=0.18u w=1.74u
M6 S net35 net45 VSS N l=0.18u w=1.08u
M7 S B net46 VSS N l=0.18u w=1.08u
M8 CO net27 VSS VSS N l=0.18u w=0.56u
M9 VDD net27 CO VDD P l=0.18u w=0.9u
M10 net35 B VSS VSS N l=0.18u w=0.48u
M11 VDD B net35 VDD P l=0.18u w=0.72u
M12 net45 net46 VSS VSS N l=0.18u w=1.2u
M13 VDD net46 net45 VDD P l=0.18u w=1.76u
M14 net46 A VSS VSS N l=0.18u w=1.56u
M15 VDD A net46 VDD P l=0.18u w=2.46u
.ends ADDHX1
*.SCALE meter
.GLOBAL GND VSS VDD

.subckt ADDHX2 CO S A B
M0 VDD A net27 VDD P l=0.18u w=0.7u
M1 VDD B net27 VDD P l=0.18u w=0.7u
M2 hnet15 A VSS VSS N l=0.18u w=0.62u
M3 net27 B hnet15 VSS N l=0.18u w=0.62u
M4 S B net45 VDD P l=0.18u w=3.5u
M5 S net35 net46 VDD P l=0.18u w=3.5u
M6 S net35 net45 VSS N l=0.18u w=2.3u
M7 S B net46 VSS N l=0.18u w=2.3u
M8 CO net27 VSS VSS N l=0.18u w=1.2u
M9 VDD net27 CO VDD P l=0.18u w=1.8u
M10 net35 B VSS VSS N l=0.18u w=0.96u
M11 VDD B net35 VDD P l=0.18u w=1.44u
M12 net45 net46 VSS VSS N l=0.18u w=2.4u
M13 VDD net46 net45 VDD P l=0.18u w=3.6u
M14 net46 A VSS VSS N l=0.18u w=3.36u
M15 VDD A net46 VDD P l=0.18u w=5.04u
.ends ADDHX2
*.SCALE meter
.GLOBAL GND VSS VDD

.subckt ADDHX4 CO S A B
M0 VDD A net27 VDD P l=0.18u w=1.36u
M1 VDD B net27 VDD P l=0.18u w=1.36u
M2 hnet15 A VSS VSS N l=0.18u w=1.2u
M3 net27 B hnet15 VSS N l=0.18u w=1.2u
M4 S B net45 VDD P l=0.18u w=6.8u
M5 S net35 net46 VDD P l=0.18u w=6.8u
M6 S net35 net45 VSS N l=0.18u w=4.8u
M7 S B net46 VSS N l=0.18u w=4.8u
M8 CO net27 VSS VSS N l=0.18u w=2.4u
M9 VDD net27 CO VDD P l=0.18u w=3.6u
M10 net35 B VSS VSS N l=0.18u w=1.88u
M11 VDD B net35 VDD P l=0.18u w=2.84u
M12 net45 net46 VSS VSS N l=0.18u w=4.8u
M13 VDD net46 net45 VDD P l=0.18u w=7.2u
M14 net46 A VSS VSS N l=0.18u w=6.5u
M15 VDD A net46 VDD P l=0.18u w=10.08u
.ends ADDHX4
*.SCALE meter
.GLOBAL GND VSS VDD

.subckt ADDHXL CO S A B
M0 VDD A net27 VDD P l=0.18u w=0.42u
M1 VDD B net27 VDD P l=0.18u w=0.42u
M2 hnet15 A VSS VSS N l=0.18u w=0.36u
M3 net27 B hnet15 VSS N l=0.18u w=0.36u
M4 S B net45 VDD P l=0.18u w=0.84u
M5 S net35 net46 VDD P l=0.18u w=0.84u
M6 S net35 net45 VSS N l=0.18u w=0.56u
M7 S B net46 VSS N l=0.18u w=0.56u
M8 CO net27 VSS VSS N l=0.18u w=0.42u
M9 VDD net27 CO VDD P l=0.18u w=0.64u
M10 net35 B VSS VSS N l=0.18u w=0.3u
M11 VDD B net35 VDD P l=0.18u w=0.42u
M12 net45 net46 VSS VSS N l=0.18u w=0.42u
M13 VDD net46 net45 VDD P l=0.18u w=0.64u
M14 net46 A VSS VSS N l=0.18u w=0.42u
M15 VDD A net46 VDD P l=0.18u w=0.64u
.ends ADDHXL
*.SCALE meter
.GLOBAL GND VSS VDD

.subckt AFCSHCINX2 CO0 CO1 S A B CI0N CI1N CS
M0 net178 CS net233 VDD P l=0.18u w=1.4u
M1 net178 net134 net227 VDD P l=0.18u w=1.4u
M2 CO1 net214 net243 VDD P l=0.18u w=1.8u
M3 CO1 net208 net229 VDD P l=0.18u w=1.78u
M4 net190 net214 net229 VDD P l=0.18u w=1.08u
M5 net190 net208 net225 VDD P l=0.18u w=1.05u
M6 CO0 net214 net219 VDD P l=0.18u w=1.8u
M7 CO0 net208 net235 VDD P l=0.18u w=1.8u
M8 net202 net214 net235 VDD P l=0.18u w=1.08u
M9 net202 net208 net231 VDD P l=0.18u w=1.05u
M10 net208 net220 net241 VDD P l=0.18u w=1.42u
M11 net208 B net239 VDD P l=0.18u w=1.42u
M12 net214 net220 net239 VDD P l=0.18u w=1.72u
M13 net214 B net241 VDD P l=0.18u w=1.72u
M14 net178 net134 net233 VSS N l=0.18u w=0.93u
M15 net178 CS net227 VSS N l=0.18u w=0.93u
M16 CO1 net208 net243 VSS N l=0.18u w=1.2u
M17 CO1 net214 net229 VSS N l=0.18u w=1.2u
M18 net190 net208 net229 VSS N l=0.18u w=0.72u
M19 net190 net214 net225 VSS N l=0.18u w=0.72u
M20 CO0 net208 net219 VSS N l=0.18u w=1.2u
M21 CO0 net214 net235 VSS N l=0.18u w=1.2u
M22 net202 net208 net235 VSS N l=0.18u w=0.72u
M23 net202 net214 net231 VSS N l=0.18u w=0.72u
M24 net208 B net241 VSS N l=0.18u w=1.2u
M25 net208 net220 net239 VSS N l=0.18u w=0.94u
M26 net214 B net239 VSS N l=0.18u w=0.87u
M27 net214 net220 net241 VSS N l=0.18u w=0.94u
M28 net215 CI1N VSS VSS N l=0.18u w=0.28u
M29 VDD CI1N net215 VDD P l=0.18u w=0.42u
M30 net217 CI0N VSS VSS N l=0.18u w=0.28u
M31 VDD CI0N net217 VDD P l=0.18u w=0.42u
M32 net219 net220 VSS VSS N l=0.18u w=1.2u
M33 VDD net220 net219 VDD P l=0.18u w=1.54u
M34 net134 CS VSS VSS N l=0.18u w=0.36u
M35 VDD CS net134 VDD P l=0.18u w=0.54u
M36 S net178 VSS VSS N l=0.18u w=1.2u
M37 VDD net178 S VDD P l=0.18u w=1.76u
M38 net225 net215 VSS VSS N l=0.18u w=0.72u
M39 VDD net215 net225 VDD P l=0.18u w=1.05u
M40 net227 net190 VSS VSS N l=0.18u w=0.93u
M41 VDD net190 net227 VDD P l=0.18u w=1.4u
M42 net229 CI1N VSS VSS N l=0.18u w=1.23u
M43 VDD CI1N net229 VDD P l=0.18u w=1.54u
M44 net231 net217 VSS VSS N l=0.18u w=0.71u
M45 VDD net217 net231 VDD P l=0.18u w=1.05u
M46 net233 net202 VSS VSS N l=0.18u w=0.93u
M47 VDD net202 net233 VDD P l=0.18u w=1.4u
M48 net235 CI0N VSS VSS N l=0.18u w=1.24u
M49 VDD CI0N net235 VDD P l=0.18u w=1.5u
M50 net220 B VSS VSS N l=0.18u w=1.24u
M51 VDD B net220 VDD P l=0.18u w=1.52u
M52 net239 A VSS VSS N l=0.18u w=1.2u
M53 VDD A net239 VDD P l=0.18u w=1.8u
M54 net241 net239 VSS VSS N l=0.18u w=1.2u
M55 VDD net239 net241 VDD P l=0.18u w=1.76u
M56 net243 net239 VSS VSS N l=0.18u w=1.2u
M57 VDD net239 net243 VDD P l=0.18u w=1.76u
.ends AFCSHCINX2
*.SCALE meter
.GLOBAL GND VSS VDD

.subckt AFCSHCINX4 CO0 CO1 S A B CI0N CI1N CS
M0 net178 CS net233 VDD P l=0.18u w=1.4u
M1 net178 net134 net227 VDD P l=0.18u w=1.4u
M2 CO1 net214 net243 VDD P l=0.18u w=1.8u
M3 CO1 net208 net229 VDD P l=0.18u w=3.6u
M4 net190 net214 net229 VDD P l=0.18u w=1.08u
M5 net190 net208 net225 VDD P l=0.18u w=1.05u
M6 CO0 net214 net219 VDD P l=0.18u w=1.8u
M7 CO0 net208 net235 VDD P l=0.18u w=3.6u
M8 net202 net214 net235 VDD P l=0.18u w=1.08u
M9 net202 net208 net231 VDD P l=0.18u w=1.05u
M10 net208 net237 net241 VDD P l=0.18u w=1.42u
M11 net208 B net239 VDD P l=0.18u w=1.42u
M12 net214 net237 net239 VDD P l=0.18u w=1.72u
M13 net214 B net241 VDD P l=0.18u w=1.72u
M14 net178 net134 net233 VSS N l=0.18u w=0.93u
M15 net178 CS net227 VSS N l=0.18u w=0.93u
M16 CO1 net208 net243 VSS N l=0.18u w=1.2u
M17 CO1 net214 net229 VSS N l=0.18u w=2.4u
M18 net190 net208 net229 VSS N l=0.18u w=0.72u
M19 net190 net214 net225 VSS N l=0.18u w=0.72u
M20 CO0 net208 net219 VSS N l=0.18u w=1.2u
M21 CO0 net214 net235 VSS N l=0.18u w=2.4u
M22 net202 net208 net235 VSS N l=0.18u w=0.72u
M23 net202 net214 net231 VSS N l=0.18u w=0.72u
M24 net208 B net241 VSS N l=0.18u w=1.2u
M25 net208 net237 net239 VSS N l=0.18u w=0.94u
M26 net214 B net239 VSS N l=0.18u w=0.87u
M27 net214 net237 net241 VSS N l=0.18u w=0.94u
M28 net215 CI1N VSS VSS N l=0.18u w=0.28u
M29 VDD CI1N net215 VDD P l=0.18u w=0.42u
M30 net217 CI0N VSS VSS N l=0.18u w=0.28u
M31 VDD CI0N net217 VDD P l=0.18u w=0.42u
M32 net219 net237 VSS VSS N l=0.18u w=1.2u
M33 VDD net237 net219 VDD P l=0.18u w=1.54u
M34 net134 CS VSS VSS N l=0.18u w=0.36u
M35 VDD CS net134 VDD P l=0.18u w=0.54u
M36 S net178 VSS VSS N l=0.18u w=1.2u
M37 VDD net178 S VDD P l=0.18u w=1.76u
M38 net225 net215 VSS VSS N l=0.18u w=0.72u
M39 VDD net215 net225 VDD P l=0.18u w=1.05u
M40 net227 net190 VSS VSS N l=0.18u w=0.93u
M41 VDD net190 net227 VDD P l=0.18u w=1.4u
M42 net229 CI1N VSS VSS N l=0.18u w=2.46u
M43 VDD CI1N net229 VDD P l=0.18u w=3.08u
M44 net231 net217 VSS VSS N l=0.18u w=0.71u
M45 VDD net217 net231 VDD P l=0.18u w=1.05u
M46 net233 net202 VSS VSS N l=0.18u w=0.93u
M47 VDD net202 net233 VDD P l=0.18u w=1.4u
M48 net235 CI0N VSS VSS N l=0.18u w=2.46u
M49 VDD CI0N net235 VDD P l=0.18u w=3u
M50 net237 B VSS VSS N l=0.18u w=1.24u
M51 VDD B net237 VDD P l=0.18u w=1.52u
M52 net239 A VSS VSS N l=0.18u w=1.2u
M53 VDD A net239 VDD P l=0.18u w=1.8u
M54 net241 net239 VSS VSS N l=0.18u w=1.2u
M55 VDD net239 net241 VDD P l=0.18u w=1.76u
M56 net243 net239 VSS VSS N l=0.18u w=1.2u
M57 VDD net239 net243 VDD P l=0.18u w=1.76u
.ends AFCSHCINX4
*.SCALE meter
.GLOBAL GND VSS VDD

.subckt AFCSHCONX2 CO0N CO1N S A B CI0 CI1 CS
M0 net158 CS net209 VDD P l=0.18u w=1.4u
M1 net158 net120 net203 VDD P l=0.18u w=1.4u
M2 CO1N net195 net193 VDD P l=0.18u w=1.78u
M3 CO1N net188 net189 VDD P l=0.18u w=1.8u
M4 net170 net195 net201 VDD P l=0.18u w=1.06u
M5 net170 net188 net205 VDD P l=0.18u w=1.08u
M6 CO0N net195 net219 VDD P l=0.18u w=1.8u
M7 CO0N net188 net191 VDD P l=0.18u w=1.8u
M8 net182 net195 net207 VDD P l=0.18u w=1.08u
M9 net182 net188 net211 VDD P l=0.18u w=1.08u
M10 net188 net213 net217 VDD P l=0.18u w=1.42u
M11 net188 B net215 VDD P l=0.18u w=1.42u
M12 net158 net120 net209 VSS N l=0.18u w=0.93u
M13 net158 CS net203 VSS N l=0.18u w=0.93u
M14 CO1N net188 net193 VSS N l=0.18u w=1.2u
M15 CO1N net195 net189 VSS N l=0.18u w=1.2u
M16 net170 net188 net201 VSS N l=0.18u w=0.72u
M17 net170 net195 net205 VSS N l=0.18u w=0.72u
M18 CO0N net188 net219 VSS N l=0.18u w=1.2u
M19 CO0N net195 net191 VSS N l=0.18u w=1.2u
M20 net182 net188 net207 VSS N l=0.18u w=0.72u
M21 net182 net195 net211 VSS N l=0.18u w=0.72u
M22 net188 B net217 VSS N l=0.18u w=1.2u
M23 net188 net213 net215 VSS N l=0.18u w=0.94u
M24 net189 CI1 VSS VSS N l=0.18u w=1.06u
M25 VDD CI1 net189 VDD P l=0.18u w=1.56u
M26 net191 CI0 VSS VSS N l=0.18u w=1.06u
M27 VDD CI0 net191 VDD P l=0.18u w=1.56u
M28 net193 B VSS VSS N l=0.18u w=1.2u
M29 VDD B net193 VDD P l=0.18u w=1.5u
M30 net195 net188 VSS VSS N l=0.18u w=1.2u
M31 VDD net188 net195 VDD P l=0.18u w=1.8u
M32 net120 CS VSS VSS N l=0.18u w=0.36u
M33 VDD CS net120 VDD P l=0.18u w=0.54u
M34 S net158 VSS VSS N l=0.18u w=1.2u
M35 VDD net158 S VDD P l=0.18u w=1.76u
M36 net201 net205 VSS VSS N l=0.18u w=0.72u
M37 VDD net205 net201 VDD P l=0.18u w=1.06u
M38 net203 net170 VSS VSS N l=0.18u w=0.93u
M39 VDD net170 net203 VDD P l=0.18u w=1.4u
M40 net205 CI1 VSS VSS N l=0.18u w=1.06u
M41 VDD CI1 net205 VDD P l=0.18u w=1.56u
M42 net207 net211 VSS VSS N l=0.18u w=0.72u
M43 VDD net211 net207 VDD P l=0.18u w=1.08u
M44 net209 net182 VSS VSS N l=0.18u w=0.9u
M45 VDD net182 net209 VDD P l=0.18u w=1.4u
M46 net211 CI0 VSS VSS N l=0.18u w=1.06u
M47 VDD CI0 net211 VDD P l=0.18u w=1.56u
M48 net213 B VSS VSS N l=0.18u w=1.23u
M49 VDD B net213 VDD P l=0.18u w=1.5u
M50 net215 A VSS VSS N l=0.18u w=1.2u
M51 VDD A net215 VDD P l=0.18u w=1.8u
M52 net217 net215 VSS VSS N l=0.18u w=1.2u
M53 VDD net215 net217 VDD P l=0.18u w=1.8u
M54 net219 A VSS VSS N l=0.18u w=1.2u
M55 VDD A net219 VDD P l=0.18u w=1.8u
.ends AFCSHCONX2
*.SCALE meter
.GLOBAL GND VSS VDD

.subckt AFCSHCONX4 CO0N CO1N S A B CI0 CI1 CS
M0 net160 CS net211 VDD P l=0.18u w=1.4u
M1 net160 net122 net205 VDD P l=0.18u w=1.4u
M2 CO1N net195 net197 VDD P l=0.18u w=1.8u
M3 CO1N net190 net191 VDD P l=0.18u w=3.6u
M4 net172 net195 net203 VDD P l=0.18u w=1.06u
M5 net172 net190 net207 VDD P l=0.18u w=1.08u
M6 CO0N net195 net221 VDD P l=0.18u w=1.8u
M7 CO0N net190 net193 VDD P l=0.18u w=3.58u
M8 net184 net195 net209 VDD P l=0.18u w=1.08u
M9 net184 net190 net213 VDD P l=0.18u w=1.08u
M10 net190 net215 net219 VDD P l=0.18u w=1.42u
M11 net190 B net217 VDD P l=0.18u w=1.42u
M12 net160 net122 net211 VSS N l=0.18u w=0.93u
M13 net160 CS net205 VSS N l=0.18u w=0.93u
M14 CO1N net190 net197 VSS N l=0.18u w=1.14u
M15 CO1N net195 net191 VSS N l=0.18u w=2.28u
M16 net172 net190 net203 VSS N l=0.18u w=0.72u
M17 net172 net195 net207 VSS N l=0.18u w=0.72u
M18 CO0N net190 net221 VSS N l=0.18u w=1.2u
M19 CO0N net195 net193 VSS N l=0.18u w=1.9u
M20 net184 net190 net209 VSS N l=0.18u w=0.72u
M21 net184 net195 net213 VSS N l=0.18u w=0.72u
M22 net190 B net219 VSS N l=0.18u w=1.2u
M23 net190 net215 net217 VSS N l=0.18u w=0.94u
M24 net191 CI1 VSS VSS N l=0.18u w=2.46u
M25 VDD CI1 net191 VDD P l=0.18u w=3.08u
M26 net193 CI0 VSS VSS N l=0.18u w=2.32u
M27 VDD CI0 net193 VDD P l=0.18u w=3.04u
M28 net195 net190 VSS VSS N l=0.18u w=1.16u
M29 VDD net190 net195 VDD P l=0.18u w=1.8u
M30 net197 B VSS VSS N l=0.18u w=1.2u
M31 VDD B net197 VDD P l=0.18u w=1.5u
M32 net122 CS VSS VSS N l=0.18u w=0.36u
M33 VDD CS net122 VDD P l=0.18u w=0.54u
M34 S net160 VSS VSS N l=0.18u w=1.2u
M35 VDD net160 S VDD P l=0.18u w=1.76u
M36 net203 net207 VSS VSS N l=0.18u w=0.72u
M37 VDD net207 net203 VDD P l=0.18u w=1.06u
M38 net205 net172 VSS VSS N l=0.18u w=0.93u
M39 VDD net172 net205 VDD P l=0.18u w=1.4u
M40 net207 CI1 VSS VSS N l=0.18u w=2.46u
M41 VDD CI1 net207 VDD P l=0.18u w=3.08u
M42 net209 net213 VSS VSS N l=0.18u w=0.72u
M43 VDD net213 net209 VDD P l=0.18u w=1.08u
M44 net211 net184 VSS VSS N l=0.18u w=0.9u
M45 VDD net184 net211 VDD P l=0.18u w=1.4u
M46 net213 CI0 VSS VSS N l=0.18u w=2.32u
M47 VDD CI0 net213 VDD P l=0.18u w=3.04u
M48 net215 B VSS VSS N l=0.18u w=1.23u
M49 VDD B net215 VDD P l=0.18u w=1.5u
M50 net217 A VSS VSS N l=0.18u w=1.2u
M51 VDD A net217 VDD P l=0.18u w=1.76u
M52 net219 net217 VSS VSS N l=0.18u w=1.2u
M53 VDD net217 net219 VDD P l=0.18u w=1.76u
M54 net221 A VSS VSS N l=0.18u w=1.2u
M55 VDD A net221 VDD P l=0.18u w=1.76u
.ends AFCSHCONX4
*.SCALE meter
.GLOBAL GND VSS VDD

.subckt AFHCINX2 CO S A B CIN
M0 net77 CIN VSS VSS N l=0.18u w=1.2u
M1 VDD CIN net77 VDD P l=0.18u w=1.76u
M2 net79 net87 VSS VSS N l=0.18u w=1.2u
M3 VDD net87 net79 VDD P l=0.18u w=1.76u
M4 net81 net85 VSS VSS N l=0.18u w=0.93u
M5 VDD net85 net81 VDD P l=0.18u w=1.4u
M6 S net128 VSS VSS N l=0.18u w=1.1u
M7 VDD net128 S VDD P l=0.18u w=1.42u
M8 net85 CIN VSS VSS N l=0.18u w=1.2u
M9 VDD CIN net85 VDD P l=0.18u w=1.76u
M10 net87 B VSS VSS N l=0.18u w=1.08u
M11 VDD B net87 VDD P l=0.18u w=1.67u
M12 net89 A VSS VSS N l=0.18u w=1.2u
M13 VDD A net89 VDD P l=0.18u w=1.76u
M14 net91 net89 VSS VSS N l=0.18u w=1.2u
M15 VDD net89 net91 VDD P l=0.18u w=1.76u
M16 CO net140 net79 VDD P l=0.18u w=1.4u
M17 CO net134 net77 VDD P l=0.18u w=1.76u
M18 net128 net140 net81 VDD P l=0.18u w=1.4u
M19 net128 net134 net85 VDD P l=0.18u w=1.4u
M20 net134 net87 net91 VDD P l=0.18u w=1.22u
M21 net134 B net89 VDD P l=0.18u w=1.22u
M22 net140 net87 net89 VDD P l=0.18u w=1.22u
M23 net140 B net91 VDD P l=0.18u w=1.5u
M24 CO net134 net79 VSS N l=0.18u w=0.93u
M25 CO net140 net77 VSS N l=0.18u w=1.2u
M26 net128 net134 net81 VSS N l=0.18u w=1.18u
M27 net128 net140 net85 VSS N l=0.18u w=1.2u
M28 net134 B net91 VSS N l=0.18u w=1.2u
M29 net134 net87 net89 VSS N l=0.18u w=0.94u
M30 net140 B net89 VSS N l=0.18u w=0.94u
M31 net140 net87 net91 VSS N l=0.18u w=0.94u
.ends AFHCINX2
*.SCALE meter
.GLOBAL GND VSS VDD

.subckt AFHCINX4 CO S A B CIN
M0 net79 CIN VSS VSS N l=0.18u w=2.4u
M1 VDD CIN net79 VDD P l=0.18u w=3.52u
M2 net81 net89 VSS VSS N l=0.18u w=1.2u
M3 VDD net89 net81 VDD P l=0.18u w=1.76u
M4 net83 net87 VSS VSS N l=0.18u w=0.93u
M5 VDD net87 net83 VDD P l=0.18u w=1.4u
M6 S net130 VSS VSS N l=0.18u w=1.2u
M7 VDD net130 S VDD P l=0.18u w=1.76u
M8 net87 CIN VSS VSS N l=0.18u w=2.4u
M9 VDD CIN net87 VDD P l=0.18u w=3.52u
M10 net89 B VSS VSS N l=0.18u w=1.08u
M11 VDD B net89 VDD P l=0.18u w=1.54u
M12 net91 A VSS VSS N l=0.18u w=1.2u
M13 VDD A net91 VDD P l=0.18u w=1.76u
M14 net93 net91 VSS VSS N l=0.18u w=1.2u
M15 VDD net91 net93 VDD P l=0.18u w=1.76u
M16 CO net142 net81 VDD P l=0.18u w=1.4u
M17 CO net136 net79 VDD P l=0.18u w=3.38u
M18 net130 net142 net83 VDD P l=0.18u w=1.4u
M19 net130 net136 net87 VDD P l=0.18u w=1.4u
M20 net136 net89 net93 VDD P l=0.18u w=1.22u
M21 net136 B net91 VDD P l=0.18u w=1.22u
M22 net142 net89 net91 VDD P l=0.18u w=1.22u
M23 net142 B net93 VDD P l=0.18u w=1.5u
M24 CO net136 net81 VSS N l=0.18u w=0.93u
M25 CO net142 net79 VSS N l=0.18u w=2.4u
M26 net130 net136 net83 VSS N l=0.18u w=1.18u
M27 net130 net142 net87 VSS N l=0.18u w=1.18u
M28 net136 B net93 VSS N l=0.18u w=1.2u
M29 net136 net89 net91 VSS N l=0.18u w=0.94u
M30 net142 B net91 VSS N l=0.18u w=0.94u
M31 net142 net89 net93 VSS N l=0.18u w=0.94u
.ends AFHCINX4
*.SCALE meter
.GLOBAL GND VSS VDD

.subckt AFHCONX2 CON S A B CI
M0 net80 CI VSS VSS N l=0.18u w=1.2u
M1 VDD CI net80 VDD P l=0.18u w=1.76u
M2 net82 B VSS VSS N l=0.18u w=1.08u
M3 VDD B net82 VDD P l=0.18u w=1.62u
M4 net84 net88 VSS VSS N l=0.18u w=0.93u
M5 VDD net88 net84 VDD P l=0.18u w=1.4u
M6 S net131 VSS VSS N l=0.18u w=0.94u
M7 VDD net131 S VDD P l=0.18u w=1.42u
M8 net88 CI VSS VSS N l=0.18u w=1.2u
M9 VDD CI net88 VDD P l=0.18u w=1.76u
M10 net90 B VSS VSS N l=0.18u w=1.08u
M11 VDD B net90 VDD P l=0.18u w=1.62u
M12 net92 A VSS VSS N l=0.18u w=1.2u
M13 VDD A net92 VDD P l=0.18u w=1.76u
M14 net94 net92 VSS VSS N l=0.18u w=1.2u
M15 VDD net92 net94 VDD P l=0.18u w=1.76u
M16 CON net143 net90 VDD P l=0.18u w=1.4u
M17 CON net137 net80 VDD P l=0.18u w=1.76u
M18 net131 net143 net88 VDD P l=0.18u w=1.34u
M19 net131 net137 net84 VDD P l=0.18u w=1.4u
M20 net137 net82 net94 VDD P l=0.18u w=1.22u
M21 net137 B net92 VDD P l=0.18u w=1.22u
M22 net143 net82 net92 VDD P l=0.18u w=1.22u
M23 net143 B net94 VDD P l=0.18u w=1.5u
M24 CON net137 net90 VSS N l=0.18u w=0.93u
M25 CON net143 net80 VSS N l=0.18u w=1.2u
M26 net131 net137 net88 VSS N l=0.18u w=0.94u
M27 net131 net143 net84 VSS N l=0.18u w=0.93u
M28 net137 B net94 VSS N l=0.18u w=1.2u
M29 net137 net82 net92 VSS N l=0.18u w=0.94u
M30 net143 B net92 VSS N l=0.18u w=0.94u
M31 net143 net82 net94 VSS N l=0.18u w=0.94u
.ends AFHCONX2
*.SCALE meter
.GLOBAL GND VSS VDD

.subckt AFHCONX4 CON S A B CI
M0 net81 CI VSS VSS N l=0.18u w=2.4u
M1 VDD CI net81 VDD P l=0.18u w=3.6u
M2 net83 B VSS VSS N l=0.18u w=1.2u
M3 VDD B net83 VDD P l=0.18u w=1.76u
M4 net85 net89 VSS VSS N l=0.18u w=0.93u
M5 VDD net89 net85 VDD P l=0.18u w=1.4u
M6 S net132 VSS VSS N l=0.18u w=0.94u
M7 VDD net132 S VDD P l=0.18u w=1.42u
M8 net89 CI VSS VSS N l=0.18u w=2.4u
M9 VDD CI net89 VDD P l=0.18u w=3.6u
M10 net91 B VSS VSS N l=0.18u w=1.2u
M11 VDD B net91 VDD P l=0.18u w=1.76u
M12 net93 A VSS VSS N l=0.18u w=1.2u
M13 VDD A net93 VDD P l=0.18u w=1.76u
M14 net95 net93 VSS VSS N l=0.18u w=1.2u
M15 VDD net93 net95 VDD P l=0.18u w=1.76u
M16 CON net144 net91 VDD P l=0.18u w=1.4u
M17 CON net138 net81 VDD P l=0.18u w=3.52u
M18 net132 net144 net89 VDD P l=0.18u w=1.34u
M19 net132 net138 net85 VDD P l=0.18u w=1.4u
M20 net138 net83 net95 VDD P l=0.18u w=1.22u
M21 net138 B net93 VDD P l=0.18u w=1.22u
M22 net144 net83 net93 VDD P l=0.18u w=1.22u
M23 net144 B net95 VDD P l=0.18u w=1.5u
M24 CON net138 net91 VSS N l=0.18u w=0.93u
M25 CON net144 net81 VSS N l=0.18u w=2.4u
M26 net132 net138 net89 VSS N l=0.18u w=0.94u
M27 net132 net144 net85 VSS N l=0.18u w=0.93u
M28 net138 B net95 VSS N l=0.18u w=1.2u
M29 net138 net83 net93 VSS N l=0.18u w=0.94u
M30 net144 B net93 VSS N l=0.18u w=0.94u
M31 net144 net83 net95 VSS N l=0.18u w=0.94u
.ends AFHCONX4
*.SCALE meter
.GLOBAL GND VSS VDD

.subckt AHHCINX2 CO S A CIN
M0 VDD CIN hnet12 VDD P l=0.18u w=1.6u
M1 hnet12 net42 CO VDD P l=0.18u w=1.6u
M2 CO CIN VSS VSS N l=0.18u w=0.9u
M3 CO net42 VSS VSS N l=0.18u w=0.9u
M4 S net30 net46 VDD P l=0.18u w=1.6u
M5 S CIN net48 VDD P l=0.18u w=1.6u
M6 S CIN net46 VSS N l=0.18u w=1.08u
M7 S net30 net48 VSS N l=0.18u w=1.08u
M8 net42 A VSS VSS N l=0.18u w=0.38u
M9 VDD A net42 VDD P l=0.18u w=0.58u
M10 net30 CIN VSS VSS N l=0.18u w=0.47u
M11 VDD CIN net30 VDD P l=0.18u w=0.7u
M12 net46 net48 VSS VSS N l=0.18u w=1.08u
M13 VDD net48 net46 VDD P l=0.18u w=1.6u
M14 net48 A VSS VSS N l=0.18u w=0.96u
M15 VDD A net48 VDD P l=0.18u w=1.45u
.ends AHHCINX2
*.SCALE meter
.GLOBAL GND VSS VDD

.subckt AHHCINX4 CO S A CIN
M0 VDD CIN hnet13 VDD P l=0.18u w=1.6u
M1 hnet13 net41 CO VDD P l=0.18u w=1.6u
M2 VDD CIN hnet11 VDD P l=0.18u w=1.6u
M3 hnet11 net41 CO VDD P l=0.18u w=1.6u
M4 CO CIN VSS VSS N l=0.18u w=1.8u
M5 CO net41 VSS VSS N l=0.18u w=1.8u
M6 S net29 net45 VDD P l=0.18u w=1.6u
M7 S CIN net47 VDD P l=0.18u w=1.6u
M8 S CIN net45 VSS N l=0.18u w=1.08u
M9 S net29 net47 VSS N l=0.18u w=1.08u
M10 net41 A VSS VSS N l=0.18u w=0.78u
M11 VDD A net41 VDD P l=0.18u w=1.16u
M12 net29 CIN VSS VSS N l=0.18u w=0.45u
M13 VDD CIN net29 VDD P l=0.18u w=0.68u
M14 net45 net47 VSS VSS N l=0.18u w=1.08u
M15 VDD net47 net45 VDD P l=0.18u w=1.6u
M16 net47 A VSS VSS N l=0.18u w=0.96u
M17 VDD A net47 VDD P l=0.18u w=1.45u
.ends AHHCINX4
*.SCALE meter
.GLOBAL GND VSS VDD

.subckt AHHCONX2 CON S A CI
M0 VDD A CON VDD P l=0.18u w=1.36u
M1 VDD CI CON VDD P l=0.18u w=1.36u
M2 hnet14 A VSS VSS N l=0.18u w=1.08u
M3 CON CI hnet14 VSS N l=0.18u w=1.08u
M4 S CI net42 VDD P l=0.18u w=1.6u
M5 S net34 net43 VDD P l=0.18u w=1.6u
M6 S net34 net42 VSS N l=0.18u w=1.08u
M7 S CI net43 VSS N l=0.18u w=1.08u
M8 net34 CI VSS VSS N l=0.18u w=0.47u
M9 VDD CI net34 VDD P l=0.18u w=0.7u
M10 net42 net43 VSS VSS N l=0.18u w=0.96u
M11 VDD net43 net42 VDD P l=0.18u w=1.45u
M12 net43 A VSS VSS N l=0.18u w=1.08u
M13 VDD A net43 VDD P l=0.18u w=1.6u
.ends AHHCONX2
*.SCALE meter
.GLOBAL GND VDD VSS

.subckt AHHCONX4 CON S A CI
M0 hnet13 A VSS VSS N l=0.18u w=1.17u
M1 CON CI hnet13 VSS N l=0.18u w=1.17u
M2 hnet18 A VSS VSS N l=0.18u w=1.17u
M3 CON CI hnet18 VSS N l=0.18u w=1.17u
M4 CON A VDD VDD P l=0.18u w=2.72u
M5 CON CI VDD VDD P l=0.18u w=2.72u
M6 S CI net57 VDD P l=0.18u w=1.6u
M7 S net49 net58 VDD P l=0.18u w=1.6u
M8 S net49 net57 VSS N l=0.18u w=1.08u
M9 S CI net58 VSS N l=0.18u w=1.08u
M10 net49 CI VSS VSS N l=0.18u w=0.47u
M11 VDD CI net49 VDD P l=0.18u w=0.7u
M12 net57 net58 VSS VSS N l=0.18u w=0.96u
M13 VDD net58 net57 VDD P l=0.18u w=1.45u
M14 net58 A VSS VSS N l=0.18u w=1.08u
M15 VDD A net58 VDD P l=0.18u w=1.6u
.ends AHHCONX4
*.SCALE meter
.GLOBAL GND VSS VDD

.subckt AND2X1 Y A B
M0 Y net11 VSS VSS N l=0.18u w=0.6u
M1 VDD net11 Y VDD P l=0.18u w=0.9u
M2 VDD B net11 VDD P l=0.18u w=0.36u
M3 VDD A net11 VDD P l=0.18u w=0.36u
M4 hnet14 B VSS VSS N l=0.18u w=0.32u
M5 net11 A hnet14 VSS N l=0.18u w=0.32u
.ends AND2X1
*.SCALE meter
.GLOBAL GND VSS VDD

.subckt AND2X2 Y A B
M0 Y net11 VSS VSS N l=0.18u w=1.2u
M1 VDD net11 Y VDD P l=0.18u w=1.7u
M2 VDD B net11 VDD P l=0.18u w=0.7u
M3 VDD A net11 VDD P l=0.18u w=0.7u
M4 hnet14 B VSS VSS N l=0.18u w=0.62u
M5 net11 A hnet14 VSS N l=0.18u w=0.62u
.ends AND2X2
*.SCALE meter
.GLOBAL GND VSS VDD

.subckt AND2X4 Y A B
M0 net21 B VDD VDD P l=0.18u w=1.2u
M1 net21 A VDD VDD P l=0.18u w=1.2u
M2 net21 A net27 VSS N l=0.19u w=1.31u
M3 net27 B VSS VSS N l=0.19u w=1.3u
M4 Y net21 VSS VSS N l=0.19u w=2.36u
M5 VDD net21 Y VDD P l=0.18u w=3.62u
.ends AND2X4
*.SCALE meter
.GLOBAL GND VSS VDD

.subckt AND2XL Y A B
M0 Y net11 VSS VSS N l=0.18u w=0.42u
M1 VDD net11 Y VDD P l=0.18u w=0.64u
M2 VDD B net11 VDD P l=0.18u w=0.42u
M3 VDD A net11 VDD P l=0.18u w=0.42u
M4 hnet14 B VSS VSS N l=0.18u w=0.32u
M5 net11 A hnet14 VSS N l=0.18u w=0.32u
.ends AND2XL
*.SCALE meter
.GLOBAL GND VSS VDD

.subckt AND3X1 Y A B C
M0 Y net14 VSS VSS N l=0.18u w=0.56u
M1 VDD net14 Y VDD P l=0.18u w=0.9u
M2 VDD C net14 VDD P l=0.18u w=0.36u
M3 VDD B net14 VDD P l=0.18u w=0.36u
M4 VDD A net14 VDD P l=0.18u w=0.36u
M5 hnet17 C VSS VSS N l=0.18u w=0.38u
M6 hnet12 B hnet17 VSS N l=0.18u w=0.38u
M7 net14 A hnet12 VSS N l=0.18u w=0.38u
.ends AND3X1
*.SCALE meter
.GLOBAL GND VSS VDD

.subckt AND3X2 Y A B C
M0 Y net14 VSS VSS N l=0.18u w=1.2u
M1 VDD net14 Y VDD P l=0.18u w=1.8u
M2 VDD C net14 VDD P l=0.18u w=0.72u
M3 VDD B net14 VDD P l=0.18u w=0.72u
M4 VDD A net14 VDD P l=0.18u w=0.72u
M5 hnet17 C VSS VSS N l=0.18u w=0.76u
M6 hnet12 B hnet17 VSS N l=0.18u w=0.76u
M7 net14 A hnet12 VSS N l=0.18u w=0.76u
.ends AND3X2
*.SCALE meter
.GLOBAL GND VSS VDD

.subckt AND3X4 Y A B C
M0 Y net14 VSS VSS N l=0.18u w=2.44u
M1 VDD net14 Y VDD P l=0.18u w=3.56u
M2 VDD C net14 VDD P l=0.18u w=1.39u
M3 VDD B net14 VDD P l=0.18u w=1.39u
M4 VDD A net14 VDD P l=0.18u w=1.39u
M5 hnet17 C VSS VSS N l=0.18u w=1.26u
M6 hnet12 B hnet17 VSS N l=0.18u w=1.26u
M7 net14 A hnet12 VSS N l=0.18u w=1.26u
.ends AND3X4
*.SCALE meter
.GLOBAL GND VSS VDD

.subckt AND3XL Y A B C
M0 Y net14 VSS VSS N l=0.18u w=0.46u
M1 VDD net14 Y VDD P l=0.18u w=0.64u
M2 VDD C net14 VDD P l=0.18u w=0.4u
M3 VDD B net14 VDD P l=0.18u w=0.4u
M4 VDD A net14 VDD P l=0.18u w=0.4u
M5 hnet17 C VSS VSS N l=0.18u w=0.44u
M6 hnet12 B hnet17 VSS N l=0.18u w=0.44u
M7 net14 A hnet12 VSS N l=0.18u w=0.44u
.ends AND3XL
*.SCALE meter
.GLOBAL GND VSS VDD

.subckt AND4X1 Y A B C D
M0 Y net17 VSS VSS N l=0.18u w=0.6u
M1 VDD net17 Y VDD P l=0.18u w=0.9u
M2 VDD D net17 VDD P l=0.18u w=0.36u
M3 VDD C net17 VDD P l=0.18u w=0.36u
M4 VDD B net17 VDD P l=0.18u w=0.36u
M5 VDD A net17 VDD P l=0.18u w=0.36u
M6 hnet15 D VSS VSS N l=0.18u w=0.4u
M7 hnet13 C hnet15 VSS N l=0.18u w=0.4u
M8 hnet14 B hnet13 VSS N l=0.18u w=0.4u
M9 net17 A hnet14 VSS N l=0.18u w=0.4u
.ends AND4X1
*.SCALE meter
.GLOBAL GND VSS VDD

.subckt AND4X2 Y A B C D
M0 Y net17 VSS VSS N l=0.18u w=1.2u
M1 VDD net17 Y VDD P l=0.18u w=1.74u
M2 VDD D net17 VDD P l=0.18u w=0.72u
M3 VDD C net17 VDD P l=0.18u w=0.72u
M4 VDD B net17 VDD P l=0.18u w=0.72u
M5 VDD A net17 VDD P l=0.18u w=0.72u
M6 hnet15 D VSS VSS N l=0.18u w=0.82u
M7 hnet13 C hnet15 VSS N l=0.18u w=0.82u
M8 hnet14 B hnet13 VSS N l=0.18u w=0.82u
M9 net17 A hnet14 VSS N l=0.18u w=0.82u
.ends AND4X2
*.SCALE meter
.GLOBAL GND VSS VDD

.subckt AND4X4 Y A B C D
M0 Y net17 VSS VSS N l=0.18u w=2.4u
M1 VDD net17 Y VDD P l=0.18u w=3.54u
M2 VDD D net17 VDD P l=0.18u w=1.29u
M3 VDD C net17 VDD P l=0.18u w=1.29u
M4 VDD B net17 VDD P l=0.18u w=1.29u
M5 VDD A net17 VDD P l=0.18u w=1.29u
M6 hnet15 D VSS VSS N l=0.18u w=0.8u
M7 hnet14 C hnet15 VSS N l=0.18u w=0.8u
M8 hnet13 B hnet14 VSS N l=0.18u w=0.8u
M9 net17 A hnet13 VSS N l=0.18u w=0.8u
M10 hnet18 D VSS VSS N l=0.18u w=0.8u
M11 hnet22 C hnet18 VSS N l=0.18u w=0.8u
M12 hnet17 B hnet22 VSS N l=0.18u w=0.8u
M13 net17 A hnet17 VSS N l=0.18u w=0.8u
.ends AND4X4
*.SCALE meter
.GLOBAL GND VSS VDD

.subckt AND4XL Y A B C D
M0 Y net17 VSS VSS N l=0.18u w=0.42u
M1 VDD net17 Y VDD P l=0.18u w=0.64u
M2 VDD D net17 VDD P l=0.18u w=0.4u
M3 VDD C net17 VDD P l=0.18u w=0.4u
M4 VDD B net17 VDD P l=0.18u w=0.4u
M5 VDD A net17 VDD P l=0.18u w=0.4u
M6 hnet15 D VSS VSS N l=0.18u w=0.48u
M7 hnet13 C hnet15 VSS N l=0.18u w=0.48u
M8 hnet14 B hnet13 VSS N l=0.18u w=0.48u
M9 net17 A hnet14 VSS N l=0.18u w=0.48u
.ends AND4XL
*.BIPOLAR
*.SCALE meter
.GLOBAL VDD GND VSS

.subckt ANTENNA A
* diode(0) = /sc_diode_i0
D_sc_diode_i0 VSS A DN 1.0764p 4.15u
.ends ANTENNA
*.SCALE meter
.GLOBAL GND VSS VDD

.subckt AOI211X1 Y A0 A1 B0 C0
M0 hnet14 A1 VSS VSS N l=0.18u w=0.8u
M1 Y A0 hnet14 VSS N l=0.18u w=0.8u
M2 Y B0 net29 VDD P l=0.18u w=1.4u
M3 net29 C0 net35 VDD P l=0.18u w=1.4u
M4 net35 A1 VDD VDD P l=0.18u w=1.42u
M5 net35 A0 VDD VDD P l=0.18u w=1.42u
M6 Y C0 VSS VSS N l=0.18u w=0.6u
M7 Y B0 VSS VSS N l=0.18u w=0.6u
.ends AOI211X1
*.SCALE meter
.GLOBAL GND VSS VDD

.subckt AOI211X2 Y A0 A1 B0 C0
M0 hnet17 A1 VSS VSS N l=0.18u w=0.8u
M1 Y A0 hnet17 VSS N l=0.18u w=0.8u
M2 hnet14 A1 VSS VSS N l=0.18u w=0.8u
M3 Y A0 hnet14 VSS N l=0.18u w=0.8u
M4 Y B0 net30 VDD P l=0.18u w=1.4u
M5 net30 C0 net42 VDD P l=0.18u w=1.4u
M6 Y B0 net36 VDD P l=0.18u w=1.4u
M7 net36 C0 net42 VDD P l=0.18u w=1.4u
M8 net42 A1 VDD VDD P l=0.18u w=2.8u
M9 net42 A0 VDD VDD P l=0.18u w=2.8u
M10 Y C0 VSS VSS N l=0.18u w=1.2u
M11 Y B0 VSS VSS N l=0.18u w=1.2u
.ends AOI211X2
*.SCALE meter
.GLOBAL GND VSS VDD

.subckt AOI211X4 Y A0 A1 B0 C0
M0 net22 net26 VSS VSS N l=0.18u w=0.96u
M1 VDD net26 net22 VDD P l=0.18u w=1.44u
M2 Y net22 VSS VSS N l=0.18u w=2.4u
M3 VDD net22 Y VDD P l=0.18u w=3.6u
M4 hnet20 A1 VSS VSS N l=0.18u w=0.5u
M5 net26 A0 hnet20 VSS N l=0.18u w=0.5u
M6 net26 B0 net30 VDD P l=0.18u w=0.88u
M7 net30 C0 net40 VDD P l=0.18u w=0.88u
M8 net40 A1 VDD VDD P l=0.18u w=0.88u
M9 net40 A0 VDD VDD P l=0.18u w=0.88u
M10 net26 C0 VSS VSS N l=0.18u w=0.38u
M11 net26 B0 VSS VSS N l=0.18u w=0.38u
.ends AOI211X4
*.SCALE meter
.GLOBAL GND VSS VDD

.subckt AOI211XL Y A0 A1 B0 C0
M0 hnet14 A1 VSS VSS N l=0.18u w=0.56u
M1 Y A0 hnet14 VSS N l=0.18u w=0.56u
M2 Y B0 net29 VDD P l=0.18u w=0.98u
M3 net29 C0 net35 VDD P l=0.18u w=0.98u
M4 net35 A1 VDD VDD P l=0.18u w=0.98u
M5 net35 A0 VDD VDD P l=0.18u w=0.98u
M6 Y C0 VSS VSS N l=0.18u w=0.42u
M7 Y B0 VSS VSS N l=0.18u w=0.42u
.ends AOI211XL
*.SCALE meter
.GLOBAL GND VSS VDD

.subckt AOI21X1 Y A0 A1 B0
M0 hnet12 A1 VSS VSS N l=0.18u w=0.8u
M1 Y A0 hnet12 VSS N l=0.18u w=0.8u
M2 Y B0 net29 VDD P l=0.18u w=1.2u
M3 net29 A1 VDD VDD P l=0.18u w=1.2u
M4 net29 A0 VDD VDD P l=0.18u w=1.2u
M5 Y B0 VSS VSS N l=0.18u w=0.6u
.ends AOI21X1
*.SCALE meter
.GLOBAL GND VSS VDD

.subckt AOI21X2 Y A0 A1 B0
M0 hnet14 A1 VSS VSS N l=0.18u w=0.8u
M1 Y A0 hnet14 VSS N l=0.18u w=0.8u
M2 hnet11 A1 VSS VSS N l=0.18u w=0.8u
M3 Y A0 hnet11 VSS N l=0.18u w=0.8u
M4 Y B0 net29 VDD P l=0.18u w=2.4u
M5 net29 A1 VDD VDD P l=0.18u w=2.4u
M6 net29 A0 VDD VDD P l=0.18u w=2.4u
M7 Y B0 VSS VSS N l=0.18u w=1.2u
.ends AOI21X2
*.SCALE meter
.GLOBAL GND VSS VDD

.subckt AOI21X4 Y A0 A1 B0
M0 hnet15 A1 VSS VSS N l=0.18u w=1.06u
M1 Y A0 hnet15 VSS N l=0.18u w=1.06u
M2 hnet11 A1 VSS VSS N l=0.18u w=1.06u
M3 Y A0 hnet11 VSS N l=0.18u w=1.06u
M4 hnet14 A1 VSS VSS N l=0.18u w=1.06u
M5 Y A0 hnet14 VSS N l=0.18u w=1.06u
M6 Y B0 net29 VDD P l=0.18u w=4.48u
M7 net29 A1 VDD VDD P l=0.18u w=4.8u
M8 net29 A0 VDD VDD P l=0.18u w=4.8u
M9 Y B0 VSS VSS N l=0.18u w=2.4u
.ends AOI21X4
*.SCALE meter
.GLOBAL GND VSS VDD

.subckt AOI21XL Y A0 A1 B0
M0 hnet12 A1 VSS VSS N l=0.18u w=0.56u
M1 Y A0 hnet12 VSS N l=0.18u w=0.56u
M2 net23 A0 VDD VDD P l=0.18u w=0.84u
M3 Y B0 net23 VDD P l=0.18u w=0.84u
M4 net23 A1 VDD VDD P l=0.18u w=0.84u
M5 Y B0 VSS VSS N l=0.18u w=0.42u
.ends AOI21XL
*.SCALE meter
.GLOBAL GND VSS VDD

.subckt AOI221X1 Y A0 A1 B0 B1 C0
M0 hnet15 B1 VSS VSS N l=0.18u w=0.8u
M1 Y B0 hnet15 VSS N l=0.18u w=0.8u
M2 hnet19 A1 VSS VSS N l=0.18u w=0.8u
M3 Y A0 hnet19 VSS N l=0.18u w=0.8u
M4 Y C0 VSS VSS N l=0.18u w=0.6u
M5 Y C0 net46 VDD P l=0.18u w=1.4u
M6 net43 B0 VDD VDD P l=0.18u w=1.4u
M7 net46 A0 net43 VDD P l=0.18u w=1.4u
M8 net43 B1 VDD VDD P l=0.18u w=1.4u
M9 net46 A1 net43 VDD P l=0.18u w=1.4u
.ends AOI221X1
*.SCALE meter
.GLOBAL GND VSS VDD

.subckt AOI221X2 Y A0 A1 B0 B1 C0
M0 hnet17 B1 VSS VSS N l=0.18u w=0.8u
M1 Y B0 hnet17 VSS N l=0.18u w=0.8u
M2 hnet14 B1 VSS VSS N l=0.18u w=0.8u
M3 Y B0 hnet14 VSS N l=0.18u w=0.8u
M4 hnet22 A1 VSS VSS N l=0.18u w=0.8u
M5 Y A0 hnet22 VSS N l=0.18u w=0.8u
M6 hnet19 A1 VSS VSS N l=0.18u w=0.8u
M7 Y A0 hnet19 VSS N l=0.18u w=0.8u
M8 Y C0 VSS VSS N l=0.18u w=1.2u
M9 Y C0 net46 VDD P l=0.18u w=2.8u
M10 net43 B0 VDD VDD P l=0.18u w=2.8u
M11 net46 A0 net43 VDD P l=0.18u w=2.8u
M12 net43 B1 VDD VDD P l=0.18u w=2.8u
M13 net46 A1 net43 VDD P l=0.18u w=2.8u
.ends AOI221X2
*.SCALE meter
.GLOBAL GND VSS VDD

.subckt AOI221X4 Y A0 A1 B0 B1 C0
M0 net24 net28 VSS VSS N l=0.18u w=0.96u
M1 VDD net28 net24 VDD P l=0.18u w=1.44u
M2 Y net24 VSS VSS N l=0.18u w=2.4u
M3 VDD net24 Y VDD P l=0.18u w=3.48u
M4 hnet21 B1 VSS VSS N l=0.18u w=0.5u
M5 net28 B0 hnet21 VSS N l=0.18u w=0.5u
M6 hnet25 A1 VSS VSS N l=0.18u w=0.5u
M7 net28 A0 hnet25 VSS N l=0.18u w=0.5u
M8 net28 C0 VSS VSS N l=0.18u w=0.38u
M9 net28 C0 net51 VDD P l=0.18u w=0.88u
M10 net48 B0 VDD VDD P l=0.18u w=0.88u
M11 net51 A0 net48 VDD P l=0.18u w=0.88u
M12 net48 B1 VDD VDD P l=0.18u w=0.88u
M13 net51 A1 net48 VDD P l=0.18u w=0.88u
.ends AOI221X4
*.SCALE meter
.GLOBAL GND VSS VDD

.subckt AOI221XL Y A0 A1 B0 B1 C0
M0 hnet15 B1 VSS VSS N l=0.18u w=0.56u
M1 Y B0 hnet15 VSS N l=0.18u w=0.56u
M2 hnet19 A1 VSS VSS N l=0.18u w=0.56u
M3 Y A0 hnet19 VSS N l=0.18u w=0.56u
M4 Y C0 VSS VSS N l=0.18u w=0.42u
M5 Y C0 net46 VDD P l=0.18u w=1u
M6 net43 B0 VDD VDD P l=0.18u w=1u
M7 net46 A0 net43 VDD P l=0.18u w=1u
M8 net43 B1 VDD VDD P l=0.18u w=1u
M9 net46 A1 net43 VDD P l=0.18u w=1u
.ends AOI221XL
*.SCALE meter
.GLOBAL GND VDD VSS

.subckt AOI222X1 Y A0 A1 B0 B1 C0 C1
M0 hnet15 C1 VSS VSS N l=0.18u w=0.8u
M1 Y C0 hnet15 VSS N l=0.18u w=0.8u
M2 hnet20 B1 VSS VSS N l=0.18u w=0.8u
M3 Y B0 hnet20 VSS N l=0.18u w=0.8u
M4 hnet25 A1 VSS VSS N l=0.18u w=0.8u
M5 Y A0 hnet25 VSS N l=0.18u w=0.8u
M6 net46 B0 net55 VDD P l=0.18u w=1.4u
M7 net46 B1 net55 VDD P l=0.18u w=1.4u
M8 net55 C0 VDD VDD P l=0.18u w=1.4u
M9 Y A0 net46 VDD P l=0.18u w=1.4u
M10 net55 C1 VDD VDD P l=0.18u w=1.4u
M11 Y A1 net46 VDD P l=0.18u w=1.4u
.ends AOI222X1
*.SCALE meter
.GLOBAL GND VDD VSS

.subckt AOI222X2 Y A0 A1 B0 B1 C0 C1
M0 hnet18 C1 VSS VSS N l=0.18u w=0.8u
M1 Y C0 hnet18 VSS N l=0.18u w=0.8u
M2 hnet14 C1 VSS VSS N l=0.18u w=0.8u
M3 Y C0 hnet14 VSS N l=0.18u w=0.8u
M4 hnet24 B1 VSS VSS N l=0.18u w=0.8u
M5 Y B0 hnet24 VSS N l=0.18u w=0.8u
M6 hnet20 B1 VSS VSS N l=0.18u w=0.8u
M7 Y B0 hnet20 VSS N l=0.18u w=0.8u
M8 hnet30 A1 VSS VSS N l=0.18u w=0.8u
M9 Y A0 hnet30 VSS N l=0.18u w=0.8u
M10 hnet26 A1 VSS VSS N l=0.18u w=0.8u
M11 Y A0 hnet26 VSS N l=0.18u w=0.8u
M12 net46 B0 net55 VDD P l=0.18u w=2.8u
M13 net46 B1 net55 VDD P l=0.18u w=2.8u
M14 net55 C0 VDD VDD P l=0.18u w=2.8u
M15 Y A0 net46 VDD P l=0.18u w=2.8u
M16 net55 C1 VDD VDD P l=0.18u w=2.8u
M17 Y A1 net46 VDD P l=0.18u w=2.8u
.ends AOI222X2
*.SCALE meter
.GLOBAL GND VDD VSS

.subckt AOI222X4 Y A0 A1 B0 B1 C0 C1
M0 net33 net37 VSS VSS N l=0.18u w=0.96u
M1 VDD net37 net33 VDD P l=0.18u w=1.4u
M2 Y net33 VSS VSS N l=0.18u w=2.4u
M3 VDD net33 Y VDD P l=0.18u w=3.54u
M4 hnet23 C1 VSS VSS N l=0.18u w=0.5u
M5 net37 C0 hnet23 VSS N l=0.18u w=0.5u
M6 hnet27 B1 VSS VSS N l=0.18u w=0.5u
M7 net37 B0 hnet27 VSS N l=0.18u w=0.5u
M8 hnet31 A1 VSS VSS N l=0.18u w=0.5u
M9 net37 A0 hnet31 VSS N l=0.18u w=0.5u
M10 net51 B0 net60 VDD P l=0.18u w=0.88u
M11 net51 B1 net60 VDD P l=0.18u w=0.88u
M12 net60 C0 VDD VDD P l=0.18u w=0.88u
M13 net37 A0 net51 VDD P l=0.18u w=0.88u
M14 net60 C1 VDD VDD P l=0.18u w=0.88u
M15 net37 A1 net51 VDD P l=0.18u w=0.88u
.ends AOI222X4
*.SCALE meter
.GLOBAL GND VDD VSS

.subckt AOI222XL Y A0 A1 B0 B1 C0 C1
M0 hnet15 C1 VSS VSS N l=0.18u w=0.56u
M1 Y C0 hnet15 VSS N l=0.18u w=0.56u
M2 hnet20 B1 VSS VSS N l=0.18u w=0.56u
M3 Y B0 hnet20 VSS N l=0.18u w=0.56u
M4 hnet25 A1 VSS VSS N l=0.18u w=0.56u
M5 Y A0 hnet25 VSS N l=0.18u w=0.56u
M6 net43 C1 VDD VDD P l=0.18u w=0.96u
M7 net49 B0 net43 VDD P l=0.18u w=0.96u
M8 net49 B1 net43 VDD P l=0.18u w=0.96u
M9 net43 C0 VDD VDD P l=0.18u w=0.96u
M10 Y A0 net49 VDD P l=0.18u w=0.96u
M11 Y A1 net49 VDD P l=0.18u w=0.96u
.ends AOI222XL
*.SCALE meter
.GLOBAL GND VDD VSS

.subckt AOI22X1 Y A0 A1 B0 B1
M0 hnet12 A1 VSS VSS N l=0.18u w=0.8u
M1 Y A0 hnet12 VSS N l=0.18u w=0.8u
M2 hnet17 B1 VSS VSS N l=0.18u w=0.8u
M3 Y B0 hnet17 VSS N l=0.18u w=0.8u
M4 net30 B0 VDD VDD P l=0.18u w=1.2u
M5 Y A0 net30 VDD P l=0.18u w=1.2u
M6 net30 B1 VDD VDD P l=0.18u w=1.2u
M7 Y A1 net30 VDD P l=0.18u w=1.2u
.ends AOI22X1
*.SCALE meter
.GLOBAL GND VDD VSS

.subckt AOI22X2 Y A0 A1 B0 B1
M0 hnet15 A1 VSS VSS N l=0.18u w=0.8u
M1 Y A0 hnet15 VSS N l=0.18u w=0.8u
M2 hnet11 A1 VSS VSS N l=0.18u w=0.8u
M3 Y A0 hnet11 VSS N l=0.18u w=0.8u
M4 hnet21 B1 VSS VSS N l=0.18u w=0.8u
M5 Y B0 hnet21 VSS N l=0.18u w=0.8u
M6 hnet17 B1 VSS VSS N l=0.18u w=0.8u
M7 Y B0 hnet17 VSS N l=0.18u w=0.8u
M8 net30 B0 VDD VDD P l=0.18u w=2.4u
M9 Y A0 net30 VDD P l=0.18u w=2.4u
M10 net30 B1 VDD VDD P l=0.18u w=2.4u
M11 Y A1 net30 VDD P l=0.18u w=2.4u
.ends AOI22X2
*.SCALE meter
.GLOBAL GND VDD VSS

.subckt AOI22X4 Y A0 A1 B0 B1
M0 hnet16 A1 VSS VSS N l=0.18u w=1.06u
M1 Y A0 hnet16 VSS N l=0.18u w=1.06u
M2 hnet11 A1 VSS VSS N l=0.18u w=1.06u
M3 Y A0 hnet11 VSS N l=0.18u w=1.06u
M4 hnet15 A1 VSS VSS N l=0.18u w=1.06u
M5 Y A0 hnet15 VSS N l=0.18u w=1.06u
M6 hnet23 B1 VSS VSS N l=0.18u w=1.06u
M7 Y B0 hnet23 VSS N l=0.18u w=1.06u
M8 hnet18 B1 VSS VSS N l=0.18u w=1.06u
M9 Y B0 hnet18 VSS N l=0.18u w=1.06u
M10 hnet22 B1 VSS VSS N l=0.18u w=1.06u
M11 Y B0 hnet22 VSS N l=0.18u w=1.06u
M12 net30 B0 VDD VDD P l=0.18u w=4.8u
M13 Y A0 net30 VDD P l=0.18u w=4.56u
M14 net30 B1 VDD VDD P l=0.18u w=4.8u
M15 Y A1 net30 VDD P l=0.18u w=4.8u
.ends AOI22X4
*.SCALE meter
.GLOBAL GND VDD VSS

.subckt AOI22XL Y A0 A1 B0 B1
M0 hnet12 A1 VSS VSS N l=0.18u w=0.56u
M1 Y A0 hnet12 VSS N l=0.18u w=0.56u
M2 hnet17 B1 VSS VSS N l=0.18u w=0.56u
M3 Y B0 hnet17 VSS N l=0.18u w=0.56u
M4 net30 B0 VDD VDD P l=0.18u w=0.84u
M5 Y A0 net30 VDD P l=0.18u w=0.84u
M6 net30 B1 VDD VDD P l=0.18u w=0.84u
M7 Y A1 net30 VDD P l=0.18u w=0.84u
.ends AOI22XL
*.SCALE meter
.GLOBAL GND VSS VDD

.subckt AOI2BB1X1 Y A0N A1N B0
M0 VDD B0 hnet9 VDD P l=0.18u w=1.18u
M1 hnet9 net13 Y VDD P l=0.18u w=1.18u
M2 Y B0 VSS VSS N l=0.18u w=0.58u
M3 Y net13 VSS VSS N l=0.18u w=0.58u
M4 VDD A1N hnet15 VDD P l=0.18u w=0.56u
M5 hnet15 A0N net13 VDD P l=0.18u w=0.56u
M6 net13 A1N VSS VSS N l=0.18u w=0.3u
M7 net13 A0N VSS VSS N l=0.18u w=0.3u
.ends AOI2BB1X1
*.SCALE meter
.GLOBAL GND VSS VDD

.subckt AOI2BB1X2 Y A0N A1N B0
M0 VDD B0 hnet10 VDD P l=0.18u w=1.2u
M1 hnet10 net13 Y VDD P l=0.18u w=1.2u
M2 VDD B0 hnet8 VDD P l=0.18u w=1.2u
M3 hnet8 net13 Y VDD P l=0.18u w=1.2u
M4 Y B0 VSS VSS N l=0.18u w=1.2u
M5 Y net13 VSS VSS N l=0.18u w=1.2u
M6 VDD A1N hnet16 VDD P l=0.18u w=1.16u
M7 hnet16 A0N net13 VDD P l=0.18u w=1.16u
M8 net13 A1N VSS VSS N l=0.18u w=0.58u
M9 net13 A0N VSS VSS N l=0.18u w=0.58u
.ends AOI2BB1X2
*.SCALE meter
.GLOBAL GND VSS VDD

.subckt AOI2BB1X4 Y A0N A1N B0
M0 VDD B0 hnet10 VDD P l=0.18u w=1.6u
M1 hnet10 net13 Y VDD P l=0.18u w=1.6u
M2 VDD B0 hnet8 VDD P l=0.18u w=1.6u
M3 hnet8 net13 Y VDD P l=0.18u w=1.6u
M4 VDD B0 hnet12 VDD P l=0.18u w=1.6u
M5 hnet12 net13 Y VDD P l=0.18u w=1.6u
M6 Y B0 VSS VSS N l=0.18u w=2.4u
M7 Y net13 VSS VSS N l=0.18u w=2.4u
M8 VDD A1N hnet18 VDD P l=0.18u w=1.14u
M9 hnet18 A0N net13 VDD P l=0.18u w=1.14u
M10 VDD A1N hnet16 VDD P l=0.18u w=1.14u
M11 hnet16 A0N net13 VDD P l=0.18u w=1.14u
M12 net13 A1N VSS VSS N l=0.18u w=1.14u
M13 net13 A0N VSS VSS N l=0.18u w=1.14u
.ends AOI2BB1X4
*.SCALE meter
.GLOBAL GND VSS VDD

.subckt AOI2BB1XL Y A0N A1N B0
M0 VDD B0 hnet9 VDD P l=0.18u w=0.84u
M1 hnet9 net13 Y VDD P l=0.18u w=0.84u
M2 Y B0 VSS VSS N l=0.18u w=0.46u
M3 Y net13 VSS VSS N l=0.18u w=0.46u
M4 VDD A1N hnet15 VDD P l=0.18u w=0.56u
M5 hnet15 A0N net13 VDD P l=0.18u w=0.56u
M6 net13 A1N VSS VSS N l=0.18u w=0.3u
M7 net13 A0N VSS VSS N l=0.18u w=0.3u
.ends AOI2BB1XL
*.SCALE meter
.GLOBAL GND VSS VDD

.subckt AOI2BB2X1 Y A0N A1N B0 B1
M0 hnet14 B1 VSS VSS N l=0.18u w=0.8u
M1 Y B0 hnet14 VSS N l=0.18u w=0.8u
M2 VDD A1N hnet17 VDD P l=0.18u w=0.56u
M3 hnet17 A0N net26 VDD P l=0.18u w=0.56u
M4 net26 A1N VSS VSS N l=0.18u w=0.3u
M5 net26 A0N VSS VSS N l=0.18u w=0.3u
M6 Y net26 VSS VSS N l=0.18u w=0.6u
M7 Y net26 net40 VDD P l=0.18u w=1.2u
M8 net40 B0 VDD VDD P l=0.18u w=1.2u
M9 net40 B1 VDD VDD P l=0.18u w=1.2u
.ends AOI2BB2X1
*.SCALE meter
.GLOBAL GND VSS VDD

.subckt AOI2BB2X2 Y A0N A1N B0 B1
M0 hnet16 B1 VSS VSS N l=0.18u w=0.8u
M1 Y B0 hnet16 VSS N l=0.18u w=0.8u
M2 hnet13 B1 VSS VSS N l=0.18u w=0.8u
M3 Y B0 hnet13 VSS N l=0.18u w=0.8u
M4 VDD A1N hnet18 VDD P l=0.18u w=1.16u
M5 hnet18 A0N net26 VDD P l=0.18u w=1.16u
M6 net26 A1N VSS VSS N l=0.18u w=0.58u
M7 net26 A0N VSS VSS N l=0.18u w=0.58u
M8 Y net26 VSS VSS N l=0.18u w=1.16u
M9 Y net26 net40 VDD P l=0.18u w=2.4u
M10 net40 B0 VDD VDD P l=0.18u w=2.4u
M11 net40 B1 VDD VDD P l=0.18u w=2.4u
.ends AOI2BB2X2
*.SCALE meter
.GLOBAL GND VSS VDD

.subckt AOI2BB2X4 Y A0N A1N B0 B1
M0 hnet17 B1 VSS VSS N l=0.18u w=1.06u
M1 Y B0 hnet17 VSS N l=0.18u w=1.06u
M2 hnet13 B1 VSS VSS N l=0.18u w=1.06u
M3 Y B0 hnet13 VSS N l=0.18u w=1.06u
M4 hnet16 B1 VSS VSS N l=0.18u w=1.06u
M5 Y B0 hnet16 VSS N l=0.18u w=1.06u
M6 VDD A1N hnet20 VDD P l=0.18u w=1.14u
M7 hnet20 A0N net26 VDD P l=0.18u w=1.14u
M8 VDD A1N hnet18 VDD P l=0.18u w=1.14u
M9 hnet18 A0N net26 VDD P l=0.18u w=1.14u
M10 net26 A1N VSS VSS N l=0.18u w=1.08u
M11 net26 A0N VSS VSS N l=0.18u w=1.08u
M12 Y net26 VSS VSS N l=0.18u w=2.4u
M13 Y net26 net40 VDD P l=0.18u w=4.8u
M14 net40 B0 VDD VDD P l=0.18u w=4.8u
M15 net40 B1 VDD VDD P l=0.18u w=4.8u
.ends AOI2BB2X4
*.SCALE meter
.GLOBAL GND VSS VDD

.subckt AOI2BB2XL Y A0N A1N B0 B1
M0 hnet14 B1 VSS VSS N l=0.18u w=0.56u
M1 Y B0 hnet14 VSS N l=0.18u w=0.56u
M2 VDD A1N hnet17 VDD P l=0.18u w=0.56u
M3 hnet17 A0N net26 VDD P l=0.18u w=0.56u
M4 net26 A1N VSS VSS N l=0.18u w=0.3u
M5 net26 A0N VSS VSS N l=0.18u w=0.3u
M6 Y net26 VSS VSS N l=0.18u w=0.42u
M7 Y net26 net40 VDD P l=0.18u w=0.84u
M8 net40 B0 VDD VDD P l=0.18u w=0.84u
M9 net40 B1 VDD VDD P l=0.18u w=0.84u
.ends AOI2BB2XL
*.SCALE meter
.GLOBAL GND VSS VDD

.subckt AOI31X1 Y A0 A1 A2 B0
M0 hnet15 A2 VSS VSS N l=0.18u w=0.96u
M1 hnet11 A1 hnet15 VSS N l=0.18u w=0.96u
M2 Y A0 hnet11 VSS N l=0.18u w=0.96u
M3 net23 A0 VDD VDD P l=0.18u w=1.2u
M4 Y B0 net23 VDD P l=0.18u w=1.2u
M5 net23 A2 VDD VDD P l=0.18u w=1.2u
M6 net23 A1 VDD VDD P l=0.18u w=1.2u
M7 Y B0 VSS VSS N l=0.18u w=0.6u
.ends AOI31X1
*.SCALE meter
.GLOBAL GND VSS VDD

.subckt AOI31X2 Y A0 A1 A2 B0
M0 hnet17 A2 VSS VSS N l=0.18u w=0.96u
M1 hnet11 A1 hnet17 VSS N l=0.18u w=0.96u
M2 Y A0 hnet11 VSS N l=0.18u w=0.96u
M3 hnet18 A2 VSS VSS N l=0.18u w=0.96u
M4 hnet13 A1 hnet18 VSS N l=0.18u w=0.96u
M5 Y A0 hnet13 VSS N l=0.18u w=0.96u
M6 net23 A0 VDD VDD P l=0.18u w=2.4u
M7 Y B0 net23 VDD P l=0.18u w=2.4u
M8 net23 A2 VDD VDD P l=0.18u w=2.4u
M9 net23 A1 VDD VDD P l=0.18u w=2.4u
M10 Y B0 VSS VSS N l=0.18u w=1.2u
.ends AOI31X2
*.SCALE meter
.GLOBAL GND VSS VDD

.subckt AOI31X4 Y A0 A1 A2 B0
M0 net18 net22 VSS VSS N l=0.18u w=0.96u
M1 VDD net22 net18 VDD P l=0.18u w=1.44u
M2 Y net18 VSS VSS N l=0.18u w=2.4u
M3 VDD net18 Y VDD P l=0.18u w=3.6u
M4 hnet21 A2 VSS VSS N l=0.18u w=0.6u
M5 hnet17 A1 hnet21 VSS N l=0.18u w=0.6u
M6 net22 A0 hnet17 VSS N l=0.18u w=0.6u
M7 net28 A0 VDD VDD P l=0.18u w=0.76u
M8 net22 B0 net28 VDD P l=0.18u w=0.76u
M9 net28 A2 VDD VDD P l=0.18u w=0.76u
M10 net28 A1 VDD VDD P l=0.18u w=0.76u
M11 net22 B0 VSS VSS N l=0.18u w=0.38u
.ends AOI31X4
*.SCALE meter
.GLOBAL GND VSS VDD

.subckt AOI31XL Y A0 A1 A2 B0
M0 hnet15 A2 VSS VSS N l=0.18u w=0.66u
M1 hnet11 A1 hnet15 VSS N l=0.18u w=0.66u
M2 Y A0 hnet11 VSS N l=0.18u w=0.66u
M3 net23 A0 VDD VDD P l=0.18u w=0.84u
M4 Y B0 net23 VDD P l=0.18u w=0.84u
M5 net23 A2 VDD VDD P l=0.18u w=0.84u
M6 net23 A1 VDD VDD P l=0.18u w=0.84u
M7 Y B0 VSS VSS N l=0.18u w=0.42u
.ends AOI31XL
*.SCALE meter
.GLOBAL GND VDD VSS

.subckt AOI32X1 Y A0 A1 A2 B0 B1
M0 hnet16 A2 VSS VSS N l=0.18u w=0.96u
M1 hnet11 A1 hnet16 VSS N l=0.18u w=0.96u
M2 Y A0 hnet11 VSS N l=0.18u w=0.96u
M3 hnet20 B1 VSS VSS N l=0.18u w=0.8u
M4 Y B0 hnet20 VSS N l=0.18u w=0.8u
M5 net37 A0 VDD VDD P l=0.18u w=1.2u
M6 net37 A1 VDD VDD P l=0.18u w=1.2u
M7 Y B0 net37 VDD P l=0.18u w=1.2u
M8 net37 A2 VDD VDD P l=0.18u w=1.2u
M9 Y B1 net37 VDD P l=0.18u w=1.2u
.ends AOI32X1
*.SCALE meter
.GLOBAL GND VDD VSS

.subckt AOI32X2 Y A0 A1 A2 B0 B1
M0 hnet18 A2 VSS VSS N l=0.18u w=0.96u
M1 hnet11 A1 hnet18 VSS N l=0.18u w=0.96u
M2 Y A0 hnet11 VSS N l=0.18u w=0.96u
M3 hnet19 A2 VSS VSS N l=0.18u w=0.96u
M4 hnet14 A1 hnet19 VSS N l=0.18u w=0.96u
M5 Y A0 hnet14 VSS N l=0.18u w=0.96u
M6 hnet24 B1 VSS VSS N l=0.18u w=0.8u
M7 Y B0 hnet24 VSS N l=0.18u w=0.8u
M8 hnet21 B1 VSS VSS N l=0.18u w=0.8u
M9 Y B0 hnet21 VSS N l=0.18u w=0.8u
M10 net37 A0 VDD VDD P l=0.18u w=2.4u
M11 net37 A1 VDD VDD P l=0.18u w=2.4u
M12 Y B0 net37 VDD P l=0.18u w=2.4u
M13 net37 A2 VDD VDD P l=0.18u w=2.4u
M14 Y B1 net37 VDD P l=0.18u w=2.4u
.ends AOI32X2
*.SCALE meter
.GLOBAL GND VDD VSS

.subckt AOI32X4 Y A0 A1 A2 B0 B1
M0 net20 net24 VSS VSS N l=0.18u w=0.96u
M1 VDD net24 net20 VDD P l=0.18u w=1.44u
M2 Y net20 VSS VSS N l=0.18u w=2.46u
M3 VDD net20 Y VDD P l=0.18u w=3.6u
M4 hnet23 A2 VSS VSS N l=0.18u w=0.6u
M5 hnet19 A1 hnet23 VSS N l=0.18u w=0.6u
M6 net24 A0 hnet19 VSS N l=0.18u w=0.6u
M7 hnet27 B1 VSS VSS N l=0.18u w=0.5u
M8 net24 B0 hnet27 VSS N l=0.18u w=0.5u
M9 net42 A0 VDD VDD P l=0.18u w=0.76u
M10 net42 A1 VDD VDD P l=0.18u w=0.76u
M11 net24 B0 net42 VDD P l=0.18u w=0.76u
M12 net42 A2 VDD VDD P l=0.18u w=0.76u
M13 net24 B1 net42 VDD P l=0.18u w=0.76u
.ends AOI32X4
*.SCALE meter
.GLOBAL GND VDD VSS

.subckt AOI32XL Y A0 A1 A2 B0 B1
M0 hnet16 A2 VSS VSS N l=0.18u w=0.66u
M1 hnet11 A1 hnet16 VSS N l=0.18u w=0.66u
M2 Y A0 hnet11 VSS N l=0.18u w=0.66u
M3 hnet20 B1 VSS VSS N l=0.18u w=0.56u
M4 Y B0 hnet20 VSS N l=0.18u w=0.56u
M5 net37 A0 VDD VDD P l=0.18u w=0.84u
M6 net37 A1 VDD VDD P l=0.18u w=0.84u
M7 Y B0 net37 VDD P l=0.18u w=0.84u
M8 net37 A2 VDD VDD P l=0.18u w=0.84u
M9 Y B1 net37 VDD P l=0.18u w=0.84u
.ends AOI32XL
*.SCALE meter
.GLOBAL GND VDD VSS

.subckt AOI33X1 Y A0 A1 A2 B0 B1 B2
M0 hnet17 B2 VSS VSS N l=0.18u w=0.96u
M1 hnet12 B1 hnet17 VSS N l=0.18u w=0.96u
M2 Y B0 hnet12 VSS N l=0.18u w=0.96u
M3 hnet24 A2 VSS VSS N l=0.18u w=0.96u
M4 hnet19 A1 hnet24 VSS N l=0.18u w=0.96u
M5 Y A0 hnet19 VSS N l=0.18u w=0.96u
M6 net46 B0 VDD VDD P l=0.18u w=1.2u
M7 Y A0 net46 VDD P l=0.18u w=1.2u
M8 net46 B1 VDD VDD P l=0.18u w=1.2u
M9 Y A1 net46 VDD P l=0.18u w=1.2u
M10 net46 B2 VDD VDD P l=0.18u w=1.2u
M11 Y A2 net46 VDD P l=0.18u w=1.2u
.ends AOI33X1
*.SCALE meter
.GLOBAL GND VDD VSS

.subckt AOI33X2 Y A0 A1 A2 B0 B1 B2
M0 hnet19 B2 VSS VSS N l=0.18u w=0.94u
M1 hnet12 B1 hnet19 VSS N l=0.18u w=0.94u
M2 Y B0 hnet12 VSS N l=0.18u w=0.94u
M3 hnet20 B2 VSS VSS N l=0.18u w=0.94u
M4 hnet15 B1 hnet20 VSS N l=0.18u w=0.94u
M5 Y B0 hnet15 VSS N l=0.18u w=0.94u
M6 hnet28 A2 VSS VSS N l=0.18u w=0.94u
M7 hnet21 A1 hnet28 VSS N l=0.18u w=0.94u
M8 Y A0 hnet21 VSS N l=0.18u w=0.94u
M9 hnet29 A2 VSS VSS N l=0.18u w=0.94u
M10 hnet24 A1 hnet29 VSS N l=0.18u w=0.94u
M11 Y A0 hnet24 VSS N l=0.18u w=0.94u
M12 net46 B0 VDD VDD P l=0.18u w=2.4u
M13 Y A0 net46 VDD P l=0.18u w=2.4u
M14 net46 B1 VDD VDD P l=0.18u w=2.4u
M15 Y A1 net46 VDD P l=0.18u w=2.4u
M16 net46 B2 VDD VDD P l=0.18u w=2.4u
M17 Y A2 net46 VDD P l=0.18u w=2.4u
.ends AOI33X2
*.SCALE meter
.GLOBAL GND VDD VSS

.subckt AOI33X4 Y A0 A1 A2 B0 B1 B2
M0 Y net27 VSS VSS N l=0.18u w=2.4u
M1 VDD net27 Y VDD P l=0.18u w=3.6u
M2 net27 net29 VSS VSS N l=0.18u w=0.96u
M3 VDD net29 net27 VDD P l=0.18u w=1.44u
M4 hnet24 B2 VSS VSS N l=0.18u w=0.6u
M5 hnet20 B1 hnet24 VSS N l=0.18u w=0.6u
M6 net29 B0 hnet20 VSS N l=0.18u w=0.6u
M7 hnet30 A2 VSS VSS N l=0.18u w=0.6u
M8 hnet26 A1 hnet30 VSS N l=0.18u w=0.6u
M9 net29 A0 hnet26 VSS N l=0.18u w=0.6u
M10 net51 B0 VDD VDD P l=0.18u w=0.76u
M11 net29 A0 net51 VDD P l=0.18u w=0.76u
M12 net51 B1 VDD VDD P l=0.18u w=0.76u
M13 net29 A1 net51 VDD P l=0.18u w=0.76u
M14 net51 B2 VDD VDD P l=0.18u w=0.76u
M15 net29 A2 net51 VDD P l=0.18u w=0.76u
.ends AOI33X4
*.SCALE meter
.GLOBAL GND VDD VSS

.subckt AOI33XL Y A0 A1 A2 B0 B1 B2
M0 hnet17 B2 VSS VSS N l=0.18u w=0.66u
M1 hnet12 B1 hnet17 VSS N l=0.18u w=0.66u
M2 Y B0 hnet12 VSS N l=0.18u w=0.66u
M3 hnet24 A2 VSS VSS N l=0.18u w=0.66u
M4 hnet19 A1 hnet24 VSS N l=0.18u w=0.66u
M5 Y A0 hnet19 VSS N l=0.18u w=0.66u
M6 net46 B0 VDD VDD P l=0.18u w=0.84u
M7 Y A0 net46 VDD P l=0.18u w=0.84u
M8 net46 B1 VDD VDD P l=0.18u w=0.84u
M9 Y A1 net46 VDD P l=0.18u w=0.84u
M10 net46 B2 VDD VDD P l=0.18u w=0.84u
M11 Y A2 net46 VDD P l=0.18u w=0.84u
.ends AOI33XL
*.SCALE meter
.GLOBAL GND VSS VDD

.subckt BENCX1 A S X2 M0 M1 M2
M0 VDD net108 hnet26 VDD P l=0.18u w=0.7u
M1 hnet26 net110 net60 VDD P l=0.18u w=0.7u
M2 VDD M1 hnet30 VDD P l=0.18u w=0.7u
M3 hnet30 M0 net63 VDD P l=0.18u w=0.7u
M4 net60 M2 VDD VDD P l=0.18u w=0.42u
M5 net63 net100 VDD VDD P l=0.18u w=0.35u
M6 net93 M1 net110 VDD P l=0.18u w=0.7u
M7 net93 net108 net106 VDD P l=0.18u w=0.7u
M8 net60 M2 net78 VSS N l=0.18u w=0.47u
M9 net78 net110 VSS VSS N l=0.18u w=0.47u
M10 net78 net108 VSS VSS N l=0.18u w=0.47u
M11 net63 net100 net87 VSS N l=0.18u w=0.47u
M12 net87 M0 VSS VSS N l=0.18u w=0.47u
M13 net87 M1 VSS VSS N l=0.18u w=0.47u
M14 net93 net108 net110 VSS N l=0.18u w=0.47u
M15 net93 M1 net106 VSS N l=0.18u w=0.47u
M16 S net102 VSS VSS N l=0.18u w=2.4u
M17 VDD net102 S VDD P l=0.18u w=3.4u
M18 A net104 VSS VSS N l=0.18u w=2.4u
M19 VDD net104 A VDD P l=0.18u w=3.6u
M20 X2 net112 VSS VSS N l=0.18u w=2.2u
M21 VDD net112 X2 VDD P l=0.18u w=3.6u
M22 net100 M2 VSS VSS N l=0.18u w=0.28u
M23 VDD M2 net100 VDD P l=0.18u w=0.42u
M24 net102 net60 VSS VSS N l=0.18u w=0.75u
M25 VDD net60 net102 VDD P l=0.18u w=1.12u
M26 net104 net63 VSS VSS N l=0.18u w=0.75u
M27 VDD net63 net104 VDD P l=0.18u w=1.12u
M28 net106 net110 VSS VSS N l=0.18u w=0.47u
M29 VDD net110 net106 VDD P l=0.18u w=0.7u
M30 net108 M1 VSS VSS N l=0.18u w=0.29u
M31 VDD M1 net108 VDD P l=0.18u w=0.44u
M32 net110 M0 VSS VSS N l=0.18u w=0.76u
M33 VDD M0 net110 VDD P l=0.18u w=1.14u
M34 net112 net93 VSS VSS N l=0.18u w=0.75u
M35 VDD net93 net112 VDD P l=0.18u w=1.12u
.ends BENCX1
*.SCALE meter
.GLOBAL GND VSS VDD

.subckt BENCX2 A S X2 M0 M1 M2
M0 net52 M0 VSS VSS N l=0.18u w=1.52u
M1 VDD M0 net52 VDD P l=0.19u w=1.72u
M2 VDD net110 hnet28 VDD P l=0.18u w=1.4u
M3 hnet28 net52 net62 VDD P l=0.18u w=1.4u
M4 VDD M1 hnet32 VDD P l=0.18u w=1.4u
M5 hnet32 M0 net65 VDD P l=0.18u w=1.4u
M6 net62 M2 VDD VDD P l=0.18u w=0.7u
M7 net65 net102 VDD VDD P l=0.18u w=0.7u
M8 net95 M1 net52 VDD P l=0.18u w=1.41u
M9 net95 net110 net108 VDD P l=0.18u w=1.41u
M10 net62 M2 net80 VSS N l=0.18u w=0.94u
M11 net80 net52 VSS VSS N l=0.18u w=0.94u
M12 net80 net110 VSS VSS N l=0.18u w=0.94u
M13 net65 net102 net89 VSS N l=0.18u w=0.94u
M14 net89 M0 VSS VSS N l=0.18u w=0.94u
M15 net89 M1 VSS VSS N l=0.18u w=0.94u
M16 net95 net110 net52 VSS N l=0.18u w=0.94u
M17 net95 M1 net108 VSS N l=0.18u w=0.94u
M18 S net104 VSS VSS N l=0.18u w=4.8u
M19 VDD net104 S VDD P l=0.18u w=7.08u
M20 A net106 VSS VSS N l=0.18u w=4.8u
M21 VDD net106 A VDD P l=0.18u w=7.08u
M22 X2 net112 VSS VSS N l=0.18u w=3.3u
M23 VDD net112 X2 VDD P l=0.18u w=7.2u
M24 net102 M2 VSS VSS N l=0.18u w=0.28u
M25 VDD M2 net102 VDD P l=0.18u w=0.42u
M26 net104 net62 VSS VSS N l=0.18u w=1.5u
M27 VDD net62 net104 VDD P l=0.18u w=2.2u
M28 net106 net65 VSS VSS N l=0.18u w=1.5u
M29 VDD net65 net106 VDD P l=0.18u w=2.17u
M30 net108 net52 VSS VSS N l=0.18u w=0.94u
M31 VDD net52 net108 VDD P l=0.18u w=1.41u
M32 net110 M1 VSS VSS N l=0.18u w=0.59u
M33 VDD M1 net110 VDD P l=0.18u w=0.88u
M34 net112 net95 VSS VSS N l=0.18u w=1.5u
M35 VDD net95 net112 VDD P l=0.18u w=2.05u
.ends BENCX2
*.SCALE meter
.GLOBAL GND VSS VDD

.subckt BENCX4 A S X2 M0 M1 M2
M0 VDD net108 hnet27 VDD P l=0.18u w=1.41u
M1 hnet27 net110 net60 VDD P l=0.18u w=1.41u
M2 VDD net108 hnet24 VDD P l=0.18u w=1.41u
M3 hnet24 net110 net60 VDD P l=0.18u w=1.41u
M4 VDD M1 hnet32 VDD P l=0.18u w=1.4u
M5 hnet32 M0 net63 VDD P l=0.18u w=1.4u
M6 VDD M1 hnet29 VDD P l=0.18u w=1.4u
M7 hnet29 M0 net63 VDD P l=0.18u w=1.4u
M8 net60 M2 VDD VDD P l=0.18u w=1.41u
M9 net63 net100 VDD VDD P l=0.18u w=1.41u
M10 net93 M1 net110 VDD P l=0.18u w=2.8u
M11 net93 net108 net106 VDD P l=0.18u w=2.8u
M12 net60 M2 net78 VSS N l=0.18u w=1.88u
M13 net78 net110 VSS VSS N l=0.18u w=1.2u
M14 net78 net108 VSS VSS N l=0.18u w=1.2u
M15 net63 net100 net87 VSS N l=0.18u w=1.88u
M16 net87 M0 VSS VSS N l=0.18u w=1.18u
M17 net87 M1 VSS VSS N l=0.18u w=1.18u
M18 net93 net108 net110 VSS N l=0.18u w=1.8u
M19 net93 M1 net106 VSS N l=0.18u w=1.8u
M20 S net102 VSS VSS N l=0.18u w=10.4u
M21 VDD net102 S VDD P l=0.18u w=14.4u
M22 A net104 VSS VSS N l=0.18u w=9.84u
M23 VDD net104 A VDD P l=0.18u w=14.32u
M24 X2 net112 VSS VSS N l=0.18u w=9.04u
M25 VDD net112 X2 VDD P l=0.18u w=15.76u
M26 net100 M2 VSS VSS N l=0.18u w=0.41u
M27 VDD M2 net100 VDD P l=0.18u w=0.62u
M28 net102 net60 VSS VSS N l=0.18u w=2.6u
M29 VDD net60 net102 VDD P l=0.18u w=3.6u
M30 net104 net63 VSS VSS N l=0.18u w=2.46u
M31 VDD net63 net104 VDD P l=0.18u w=3.58u
M32 net106 net110 VSS VSS N l=0.18u w=1.2u
M33 VDD net110 net106 VDD P l=0.18u w=2.8u
M34 net108 M1 VSS VSS N l=0.18u w=1.18u
M35 VDD M1 net108 VDD P l=0.18u w=1.7u
M36 net110 M0 VSS VSS N l=0.18u w=2.16u
M37 VDD M0 net110 VDD P l=0.18u w=3.6u
M38 net112 net93 VSS VSS N l=0.18u w=2.26u
M39 VDD net93 net112 VDD P l=0.18u w=3.94u
.ends BENCX4
*.SCALE meter
.GLOBAL GND VSS VDD

.subckt BMXX1 PP A M0 M1 S X2
M0 net58 net103 VSS VSS N l=0.18u w=0.47u
M1 VDD net103 net58 VDD P l=0.18u w=0.7u
M2 net60 net97 VSS VSS N l=0.18u w=0.47u
M3 VDD net97 net60 VDD P l=0.18u w=0.7u
M4 net62 M1 VSS VSS N l=0.18u w=0.28u
M5 VDD M1 net62 VDD P l=0.18u w=0.42u
M6 net64 M0 VSS VSS N l=0.18u w=0.28u
M7 VDD M0 net64 VDD P l=0.18u w=0.42u
M8 net66 A VSS VSS N l=0.18u w=0.73u
M9 VDD A net66 VDD P l=0.18u w=1.1u
M10 net68 S VSS VSS N l=0.18u w=0.73u
M11 VDD S net68 VDD P l=0.18u w=1.1u
M12 PP net109 VSS VSS N l=0.18u w=0.6u
M13 VDD net109 PP VDD P l=0.18u w=0.9u
M14 net89 X2 VSS VSS N l=0.18u w=0.28u
M15 VDD X2 net89 VDD P l=0.18u w=0.42u
M16 net97 M1 net68 VDD P l=0.18u w=0.55u
M17 net97 net62 net66 VDD P l=0.18u w=0.55u
M18 net103 M0 net68 VDD P l=0.18u w=0.55u
M19 net103 net64 net66 VDD P l=0.18u w=0.55u
M20 net109 X2 net60 VDD P l=0.18u w=0.7u
M21 net109 net89 net58 VDD P l=0.18u w=0.7u
M22 net97 net62 net68 VSS N l=0.18u w=0.42u
M23 net97 M1 net66 VSS N l=0.18u w=0.42u
M24 net103 net64 net68 VSS N l=0.18u w=0.42u
M25 net103 M0 net66 VSS N l=0.18u w=0.42u
M26 net109 net89 net60 VSS N l=0.18u w=0.47u
M27 net109 X2 net58 VSS N l=0.18u w=0.47u
.ends BMXX1
*.SCALE meter
.GLOBAL GND VSS VDD

.subckt BUFX1 Y A
M0 Y net7 VSS VSS N l=0.18u w=0.6u
M1 VDD net7 Y VDD P l=0.18u w=0.9u
M2 net7 A VSS VSS N l=0.18u w=0.3u
M3 VDD A net7 VDD P l=0.18u w=0.42u
.ends BUFX1
*.SCALE meter
.GLOBAL GND VSS VDD

.subckt BUFX12 Y A
M0 Y net7 VSS VSS N l=0.18u w=7.2u
M1 VDD net7 Y VDD P l=0.18u w=10.8u
M2 net7 A VSS VSS N l=0.18u w=2.82u
M3 VDD A net7 VDD P l=0.18u w=4.26u
.ends BUFX12
*.SCALE meter
.GLOBAL GND VSS VDD

.subckt BUFX16 Y A
M0 Y net7 VSS VSS N l=0.18u w=9.68u
M1 VDD net7 Y VDD P l=0.18u w=14.4u
M2 net7 A VSS VSS N l=0.18u w=3.78u
M3 VDD A net7 VDD P l=0.18u w=5.7u
.ends BUFX16
*.SCALE meter
.GLOBAL GND VSS VDD

.subckt BUFX2 Y A
M0 Y net7 VSS VSS N l=0.18u w=1.2u
M1 VDD net7 Y VDD P l=0.18u w=1.76u
M2 net7 A VSS VSS N l=0.18u w=0.48u
M3 VDD A net7 VDD P l=0.18u w=0.72u
.ends BUFX2
*.SCALE meter
.GLOBAL GND VSS VDD

.subckt BUFX20 Y A
M0 Y net7 VSS VSS N l=0.18u w=12u
M1 VDD net7 Y VDD P l=0.18u w=18u
M2 net7 A VSS VSS N l=0.18u w=4.8u
M3 VDD A net7 VDD P l=0.18u w=7.16u
.ends BUFX20
*.SCALE meter
.GLOBAL GND VSS VDD

.subckt BUFX3 Y A
M0 Y net7 VSS VSS N l=0.18u w=1.8u
M1 VDD net7 Y VDD P l=0.18u w=2.72u
M2 net7 A VSS VSS N l=0.18u w=0.72u
M3 VDD A net7 VDD P l=0.18u w=1.08u
.ends BUFX3
*.SCALE meter
.GLOBAL GND VSS VDD

.subckt BUFX4 Y A
M0 Y net7 VSS VSS N l=0.18u w=2.4u
M1 VDD net7 Y VDD P l=0.18u w=3.52u
M2 net7 A VSS VSS N l=0.18u w=0.96u
M3 VDD A net7 VDD P l=0.18u w=1.44u
.ends BUFX4
*.SCALE meter
.GLOBAL GND VSS VDD

.subckt BUFX8 Y A
M0 Y net7 VSS VSS N l=0.18u w=4.8u
M1 VDD net7 Y VDD P l=0.18u w=7.2u
M2 net7 A VSS VSS N l=0.18u w=1.92u
M3 VDD A net7 VDD P l=0.18u w=2.84u
.ends BUFX8
*.SCALE meter
.GLOBAL GND VSS VDD

.subckt BUFXL Y A
M0 Y net7 VSS VSS N l=0.18u w=0.42u
M1 VDD net7 Y VDD P l=0.18u w=0.64u
M2 net7 A VSS VSS N l=0.18u w=0.3u
M3 VDD A net7 VDD P l=0.18u w=0.42u
.ends BUFXL
*.SCALE meter
.GLOBAL GND VSS VDD

.subckt CLKBUFX1 Y A
M0 Y net7 VSS VSS N l=0.18u w=0.3u
M1 VDD net7 Y VDD P l=0.18u w=0.98u
M2 net7 A VSS VSS N l=0.18u w=0.3u
M3 VDD A net7 VDD P l=0.18u w=0.98u
.ends CLKBUFX1
*.SCALE meter
.GLOBAL GND VSS VDD

.subckt CLKBUFX12 Y A
M0 Y net7 VSS VSS N l=0.18u w=7.2u
M1 VDD net7 Y VDD P l=0.18u w=18u
M2 net7 A VSS VSS N l=0.18u w=2.4u
M3 VDD A net7 VDD P l=0.18u w=6u
.ends CLKBUFX12
*.SCALE meter
.GLOBAL GND VSS VDD

.subckt CLKBUFX16 Y A
M0 Y net7 VSS VSS N l=0.18u w=9.36u
M1 VDD net7 Y VDD P l=0.18u w=23.4u
M2 net7 A VSS VSS N l=0.18u w=2.88u
M3 VDD A net7 VDD P l=0.18u w=7.2u
.ends CLKBUFX16
*.SCALE meter
.GLOBAL GND VSS VDD

.subckt CLKBUFX2 Y A
M0 Y net7 VSS VSS N l=0.18u w=0.64u
M1 VDD net7 Y VDD P l=0.18u w=1.76u
M2 net7 A VSS VSS N l=0.18u w=0.3u
M3 VDD A net7 VDD P l=0.18u w=0.78u
.ends CLKBUFX2
*.SCALE meter
.GLOBAL GND VSS VDD

.subckt CLKBUFX20 Y A
M0 Y net7 VSS VSS N l=0.18u w=12u
M1 VDD net7 Y VDD P l=0.18u w=28.8u
M2 net7 A VSS VSS N l=0.18u w=4u
M3 VDD A net7 VDD P l=0.18u w=9.96u
.ends CLKBUFX20
*.SCALE meter
.GLOBAL GND VSS VDD

.subckt CLKBUFX3 Y A
M0 Y net7 VSS VSS N l=0.18u w=1.02u
M1 VDD net7 Y VDD P l=0.18u w=2.64u
M2 net7 A VSS VSS N l=0.18u w=0.34u
M3 VDD A net7 VDD P l=0.18u w=0.9u
.ends CLKBUFX3
*.SCALE meter
.GLOBAL GND VSS VDD

.subckt CLKBUFX4 Y A
M0 Y net7 VSS VSS N l=0.18u w=1.36u
M1 VDD net7 Y VDD P l=0.18u w=3.52u
M2 net7 A VSS VSS N l=0.18u w=0.44u
M3 VDD A net7 VDD P l=0.18u w=1.16u
.ends CLKBUFX4
*.SCALE meter
.GLOBAL GND VSS VDD

.subckt CLKBUFX8 Y A
M0 Y net7 VSS VSS N l=0.18u w=2.88u
M1 VDD net7 Y VDD P l=0.18u w=7.2u
M2 net7 A VSS VSS N l=0.18u w=0.96u
M3 VDD A net7 VDD P l=0.18u w=2.4u
.ends CLKBUFX8
*.SCALE meter
.GLOBAL GND VSS VDD

.subckt CLKBUFXL Y A
M0 Y net7 VSS VSS N l=0.18u w=0.3u
M1 VDD net7 Y VDD P l=0.18u w=1u
M2 net7 A VSS VSS N l=0.18u w=0.3u
M3 VDD A net7 VDD P l=0.18u w=0.3u
.ends CLKBUFXL
*.SCALE meter
.GLOBAL GND VSS VDD

.subckt CLKINVX1 Y A
M0 Y A VSS VSS N l=0.18u w=0.36u
M1 VDD A Y VDD P l=0.18u w=0.9u
.ends CLKINVX1
*.SCALE meter
.GLOBAL GND VSS VDD

.subckt CLKINVX12 Y A
M0 net5 A VSS VSS N l=0.18u w=0.8u
M1 VDD A net5 VDD P l=0.18u w=2.03u
M2 net10 net5 VSS VSS N l=0.19u w=2.4u
M3 VDD net5 net10 VDD P l=0.18u w=5.99u
M4 Y net10 VSS VSS N l=0.19u w=7.2u
M5 VDD net10 Y VDD P l=0.18u w=18u
.ends CLKINVX12
*.SCALE meter
.GLOBAL GND VSS VDD

.subckt CLKINVX16 Y A
M0 net10 net7 VSS VSS N l=0.19u w=3.2u
M1 VDD net7 net10 VDD P l=0.18u w=8u
M2 net7 A VSS VSS N l=0.19u w=1.06u
M3 VDD A net7 VDD P l=0.18u w=2.64u
M4 Y net10 VSS VSS N l=0.19u w=9.6u
M5 VDD net10 Y VDD P l=0.18u w=24u
.ends CLKINVX16
*.SCALE meter
.GLOBAL GND VSS VDD

.subckt CLKINVX2 Y A
M0 Y A VSS VSS N l=0.18u w=0.64u
M1 VDD A Y VDD P l=0.18u w=1.8u
.ends CLKINVX2
*.SCALE meter
.GLOBAL GND VSS VDD

.subckt CLKINVX20 Y A
M0 net10 net7 VSS VSS N l=0.19u w=4u
M1 VDD net7 net10 VDD P l=0.18u w=9.9u
M2 net7 A VSS VSS N l=0.19u w=1.32u
M3 VDD A net7 VDD P l=0.18u w=3.3u
M4 Y net10 VSS VSS N l=0.19u w=12u
M5 VDD net10 Y VDD P l=0.18u w=30u
.ends CLKINVX20
*.SCALE meter
.GLOBAL GND VSS VDD

.subckt CLKINVX3 Y A
M0 Y A VSS VSS N l=0.18u w=1.02u
M1 VDD A Y VDD P l=0.18u w=2.7u
.ends CLKINVX3
*.SCALE meter
.GLOBAL GND VSS VDD

.subckt CLKINVX4 Y A
M0 Y A VSS VSS N l=0.18u w=1.36u
M1 VDD A Y VDD P l=0.18u w=3.54u
.ends CLKINVX4
*.SCALE meter
.GLOBAL GND VSS VDD

.subckt CLKINVX8 Y A
M0 Y A VSS VSS N l=0.19u w=2.88u
M1 VDD A Y VDD P l=0.18u w=7.2u
.ends CLKINVX8
*.SCALE meter
.GLOBAL GND VSS VDD

.subckt CLKINVXL Y A
M0 Y A VSS VSS N l=0.18u w=0.28u
M1 VDD A Y VDD P l=0.18u w=0.7u
.ends CLKINVXL
*.SCALE meter
.GLOBAL GND VSS VDD

.subckt CMPR22X1 CO S A B
M0 VDD A net27 VDD P l=0.18u w=0.36u
M1 VDD B net27 VDD P l=0.18u w=0.36u
M2 hnet15 A VSS VSS N l=0.18u w=0.32u
M3 net27 B hnet15 VSS N l=0.18u w=0.32u
M4 S B net45 VDD P l=0.18u w=1.74u
M5 S net35 net46 VDD P l=0.18u w=1.74u
M6 S net35 net45 VSS N l=0.18u w=1.08u
M7 S B net46 VSS N l=0.18u w=1.08u
M8 CO net27 VSS VSS N l=0.18u w=0.56u
M9 VDD net27 CO VDD P l=0.18u w=0.9u
M10 net35 B VSS VSS N l=0.18u w=0.48u
M11 VDD B net35 VDD P l=0.18u w=0.72u
M12 net45 net46 VSS VSS N l=0.18u w=1.2u
M13 VDD net46 net45 VDD P l=0.18u w=1.76u
M14 net46 A VSS VSS N l=0.18u w=1.56u
M15 VDD A net46 VDD P l=0.18u w=2.46u
.ends CMPR22X1
*.SCALE meter
.GLOBAL GND VSS VDD

.subckt CMPR32X1 CO S A B C
M0 xo net117 net119 VDD P l=0.18u w=0.64u
M1 xn net109 net119 VDD P l=0.18u w=0.64u
M2 xn net119 net109 VDD P l=0.18u w=0.96u
M3 xo net119 net117 VDD P l=0.18u w=0.96u
M4 net115 xn net78 VDD P l=0.18u w=0.64u
M5 net78 xo net117 VDD P l=0.18u w=0.64u
M6 net108 C xn VDD P l=0.18u w=0.64u
M7 net108 net115 xo VDD P l=0.18u w=0.64u
M8 xo net109 net119 VSS N l=0.18u w=0.42u
M9 xn net117 net119 VSS N l=0.18u w=0.42u
M10 xo net119 net109 VSS N l=0.18u w=0.64u
M11 xn net119 net117 VSS N l=0.18u w=0.64u
M12 net115 xo net78 VSS N l=0.18u w=0.42u
M13 net78 xn net117 VSS N l=0.18u w=0.42u
M14 net108 net115 xn VSS N l=0.18u w=0.42u
M15 net108 C xo VSS N l=0.18u w=0.42u
M16 net109 net117 VSS VSS N l=0.18u w=0.84u
M17 VDD net117 net109 VDD P l=0.18u w=1.26u
M18 S net108 VSS VSS N l=0.18u w=0.6u
M19 VDD net108 S VDD P l=0.18u w=0.9u
M20 CO net78 VSS VSS N l=0.18u w=0.6u
M21 VDD net78 CO VDD P l=0.18u w=0.9u
M22 net115 C VSS VSS N l=0.18u w=0.42u
M23 VDD C net115 VDD P l=0.18u w=0.64u
M24 net117 B VSS VSS N l=0.18u w=1.2u
M25 VDD B net117 VDD P l=0.18u w=1.79u
M26 net119 A VSS VSS N l=0.18u w=1.2u
M27 VDD A net119 VDD P l=0.18u w=1.8u
.ends CMPR32X1
*.SCALE meter
.GLOBAL GND VSS VDD

.subckt CMPR42X1 CO ICO S A B C D ICI
M0 net92 net90 net91 VSS N l=0.18u w=0.32u
M1 net92 net144 net94 VSS N l=0.18u w=0.32u
M2 net199 B net97 VSS N l=0.18u w=0.3u
M3 net97 A VSS VSS N l=0.18u w=0.3u
M4 net104 B VSS VSS N l=0.18u w=0.3u
M5 net104 A VSS VSS N l=0.18u w=0.3u
M6 net199 C net104 VSS N l=0.18u w=0.3u
M7 net183 B net117 VSS N l=0.18u w=0.52u
M8 net183 net165 net119 VSS N l=0.18u w=0.52u
M9 net119 net117 VSS VSS N l=0.18u w=0.52u
M10 net125 D net126 VSS N l=0.18u w=0.52u
M11 net125 net91 net128 VSS N l=0.18u w=0.52u
M12 net128 net126 VSS VSS N l=0.18u w=0.52u
M13 net144 net133 net125 VSS N l=0.18u w=0.52u
M14 net144 net125 net133 VSS N l=0.18u w=0.52u
M15 net140 net90 net94 VSS N l=0.18u w=0.32u
M16 net140 net144 net139 VSS N l=0.18u w=0.32u
M17 net139 net94 VSS VSS N l=0.18u w=0.32u
M18 net92 net144 net91 VDD P l=0.18u w=0.64u
M19 net92 net90 net94 VDD P l=0.18u w=0.64u
M20 net152 A VDD VDD P l=0.18u w=0.6u
M21 net199 B net152 VDD P l=0.18u w=0.6u
M22 net199 C net161 VDD P l=0.18u w=0.6u
M23 net161 B VDD VDD P l=0.18u w=0.6u
M24 net161 A VDD VDD P l=0.18u w=0.6u
M25 net183 net165 net117 VDD P l=0.18u w=1.04u
M26 net183 B net173 VDD P l=0.18u w=1.04u
M27 net173 net117 VDD VDD P l=0.18u w=1.04u
M28 net125 net91 net126 VDD P l=0.18u w=1.04u
M29 net125 D net182 VDD P l=0.18u w=1.04u
M30 net182 net126 VDD VDD P l=0.18u w=1.04u
M31 net144 net183 net125 VDD P l=0.18u w=1.04u
M32 net144 net125 net183 VDD P l=0.18u w=1.04u
M33 net140 net144 net94 VDD P l=0.18u w=0.64u
M34 net140 net90 net193 VDD P l=0.18u w=0.64u
M35 net193 net94 VDD VDD P l=0.18u w=0.64u
M36 ICO net199 VSS VSS N l=0.18u w=0.6u
M37 VDD net199 ICO VDD P l=0.18u w=0.9u
M38 CO net92 VSS VSS N l=0.18u w=0.6u
M39 VDD net92 CO VDD P l=0.18u w=0.9u
M40 net133 net183 VSS VSS N l=0.18u w=0.52u
M41 VDD net183 net133 VDD P l=0.18u w=1.04u
M42 net117 A VSS VSS N l=0.18u w=0.52u
M43 VDD A net117 VDD P l=0.18u w=1.04u
M44 net165 B VSS VSS N l=0.18u w=0.22u
M45 VDD B net165 VDD P l=0.18u w=0.4u
M46 net126 C VSS VSS N l=0.18u w=0.52u
M47 VDD C net126 VDD P l=0.18u w=1.04u
M48 net91 D VSS VSS N l=0.18u w=0.3u
M49 VDD D net91 VDD P l=0.18u w=0.6u
M50 net90 net144 VSS VSS N l=0.18u w=0.22u
M51 VDD net144 net90 VDD P l=0.18u w=0.4u
M52 net94 ICI VSS VSS N l=0.18u w=0.32u
M53 VDD ICI net94 VDD P l=0.18u w=0.64u
M54 S net140 VSS VSS N l=0.18u w=0.6u
M55 VDD net140 S VDD P l=0.18u w=0.9u
.ends CMPR42X1
*.SCALE meter
.GLOBAL GND VSS VDD

.subckt CMPR42X2 CO ICO S A B C D ICI
M0 net92 net90 net91 VSS N l=0.18u w=0.93u
M1 net92 net144 net94 VSS N l=0.18u w=0.93u
M2 net199 B net101 VSS N l=0.18u w=0.93u
M3 net101 A VSS VSS N l=0.18u w=0.93u
M4 net104 B VSS VSS N l=0.18u w=0.93u
M5 net104 A VSS VSS N l=0.18u w=0.93u
M6 net199 C net104 VSS N l=0.18u w=0.93u
M7 net183 B net117 VSS N l=0.18u w=1.08u
M8 net183 net165 net115 VSS N l=0.18u w=1.08u
M9 net115 net117 VSS VSS N l=0.18u w=1.08u
M10 net125 D net126 VSS N l=0.18u w=1.1u
M11 net125 net91 net128 VSS N l=0.18u w=1.1u
M12 net128 net126 VSS VSS N l=0.18u w=1.1u
M13 net144 net133 net125 VSS N l=0.18u w=1.06u
M14 net144 net125 net133 VSS N l=0.18u w=1.15u
M15 net140 net90 net94 VSS N l=0.18u w=0.93u
M16 net140 net144 net139 VSS N l=0.18u w=0.93u
M17 net139 net94 VSS VSS N l=0.18u w=0.93u
M18 net92 net144 net91 VDD P l=0.18u w=1.4u
M19 net92 net90 net94 VDD P l=0.18u w=1.4u
M20 net154 A VDD VDD P l=0.18u w=1.4u
M21 net199 B net154 VDD P l=0.18u w=1.4u
M22 net199 C net161 VDD P l=0.18u w=1.4u
M23 net161 B VDD VDD P l=0.18u w=1.4u
M24 net161 A VDD VDD P l=0.18u w=1.4u
M25 net183 net165 net117 VDD P l=0.18u w=1.6u
M26 net183 B net173 VDD P l=0.18u w=1.5u
M27 net173 net117 VDD VDD P l=0.18u w=1.5u
M28 net125 net91 net126 VDD P l=0.18u w=1.56u
M29 net125 D net182 VDD P l=0.18u w=1.56u
M30 net182 net126 VDD VDD P l=0.18u w=1.56u
M31 net144 net183 net125 VDD P l=0.18u w=1.77u
M32 net144 net125 net183 VDD P l=0.18u w=1.77u
M33 net140 net144 net94 VDD P l=0.18u w=1.4u
M34 net140 net90 net197 VDD P l=0.18u w=1.4u
M35 net197 net94 VDD VDD P l=0.18u w=1.4u
M36 ICO net199 VSS VSS N l=0.18u w=1.2u
M37 VDD net199 ICO VDD P l=0.18u w=1.77u
M38 CO net92 VSS VSS N l=0.18u w=1.2u
M39 VDD net92 CO VDD P l=0.18u w=1.77u
M40 net133 net183 VSS VSS N l=0.18u w=1.15u
M41 VDD net183 net133 VDD P l=0.18u w=1.77u
M42 net117 A VSS VSS N l=0.18u w=1.1u
M43 VDD A net117 VDD P l=0.18u w=1.6u
M44 net165 B VSS VSS N l=0.18u w=0.38u
M45 VDD B net165 VDD P l=0.18u w=0.57u
M46 net126 C VSS VSS N l=0.18u w=1.1u
M47 VDD C net126 VDD P l=0.18u w=1.6u
M48 net91 D VSS VSS N l=0.18u w=1.2u
M49 VDD D net91 VDD P l=0.18u w=1.6u
M50 net90 net144 VSS VSS N l=0.18u w=0.58u
M51 VDD net144 net90 VDD P l=0.18u w=0.87u
M52 net94 ICI VSS VSS N l=0.18u w=1.1u
M53 VDD ICI net94 VDD P l=0.18u w=1.49u
M54 S net140 VSS VSS N l=0.18u w=1.14u
M55 VDD net140 S VDD P l=0.18u w=1.77u
.ends CMPR42X2
*.SCALE meter
.GLOBAL GND VSS VDD

.subckt DFFHQX1 Q CK D
M0 net46 cn net53 VDD P l=0.18u w=1.04u
M1 net46 c net53 VSS N l=0.18u w=0.7u
M2 hnet16 c pm VDD P l=0.18u w=0.42u
M3 VDD D hnet16 VDD P l=0.18u w=0.42u
M4 hnet14 D VSS VSS N l=0.18u w=0.3u
M5 pm cn hnet14 VSS N l=0.18u w=0.3u
M6 hnet24 c net46 VDD P l=0.18u w=0.3u
M7 VDD s hnet24 VDD P l=0.18u w=0.3u
M8 hnet22 s VSS VSS N l=0.18u w=0.3u
M9 net46 cn hnet22 VSS N l=0.18u w=0.3u
M10 hnet32 cn pm VDD P l=0.18u w=0.42u
M11 VDD m hnet32 VDD P l=0.18u w=0.42u
M12 hnet30 m VSS VSS N l=0.18u w=0.3u
M13 pm c hnet30 VSS N l=0.18u w=0.3u
M14 net53 m VSS VSS N l=0.18u w=0.7u
M15 VDD m net53 VDD P l=0.18u w=1.04u
M16 s net46 VSS VSS N l=0.18u w=0.3u
M17 VDD net46 s VDD P l=0.18u w=0.42u
M18 m pm VSS VSS N l=0.18u w=0.3u
M19 VDD pm m VDD P l=0.18u w=0.42u
M20 c cn VSS VSS N l=0.18u w=0.3u
M21 VDD cn c VDD P l=0.18u w=0.42u
M22 cn CK VSS VSS N l=0.18u w=0.46u
M23 VDD CK cn VDD P l=0.18u w=0.66u
M24 Q net46 VSS VSS N l=0.18u w=0.57u
M25 VDD net46 Q VDD P l=0.18u w=0.9u
.ends DFFHQX1
*.SCALE meter
.GLOBAL GND VSS VDD

.subckt DFFHQX2 Q CK D
M0 net46 cn net53 VDD P l=0.18u w=1.76u
M1 net46 c net53 VSS N l=0.18u w=1.18u
M2 hnet16 c pm VDD P l=0.18u w=0.48u
M3 VDD D hnet16 VDD P l=0.18u w=0.48u
M4 hnet14 D VSS VSS N l=0.18u w=0.32u
M5 pm cn hnet14 VSS N l=0.18u w=0.32u
M6 hnet24 c net46 VDD P l=0.18u w=0.3u
M7 VDD s hnet24 VDD P l=0.18u w=0.3u
M8 hnet22 s VSS VSS N l=0.18u w=0.3u
M9 net46 cn hnet22 VSS N l=0.18u w=0.3u
M10 hnet32 cn pm VDD P l=0.18u w=0.42u
M11 VDD m hnet32 VDD P l=0.18u w=0.42u
M12 hnet30 m VSS VSS N l=0.18u w=0.28u
M13 pm c hnet30 VSS N l=0.18u w=0.28u
M14 net53 m VSS VSS N l=0.18u w=1.18u
M15 VDD m net53 VDD P l=0.18u w=1.76u
M16 s net46 VSS VSS N l=0.18u w=0.3u
M17 VDD net46 s VDD P l=0.18u w=0.42u
M18 m pm VSS VSS N l=0.18u w=0.4u
M19 VDD pm m VDD P l=0.18u w=0.6u
M20 c cn VSS VSS N l=0.18u w=0.36u
M21 VDD cn c VDD P l=0.18u w=0.54u
M22 cn CK VSS VSS N l=0.18u w=0.58u
M23 VDD CK cn VDD P l=0.18u w=0.88u
M24 Q net46 VSS VSS N l=0.18u w=1.14u
M25 VDD net46 Q VDD P l=0.18u w=1.8u
.ends DFFHQX2
*.SCALE meter
.GLOBAL GND VSS VDD

.subckt DFFHQX4 Q CK D
M0 net46 cn net53 VDD P l=0.18u w=2.88u
M1 net46 c net53 VSS N l=0.18u w=1.9u
M2 hnet16 c pm VDD P l=0.18u w=0.78u
M3 VDD D hnet16 VDD P l=0.18u w=0.78u
M4 hnet14 D VSS VSS N l=0.18u w=0.52u
M5 pm cn hnet14 VSS N l=0.18u w=0.52u
M6 hnet24 c net46 VDD P l=0.18u w=0.3u
M7 VDD s hnet24 VDD P l=0.18u w=0.3u
M8 hnet22 s VSS VSS N l=0.18u w=0.3u
M9 net46 cn hnet22 VSS N l=0.18u w=0.3u
M10 hnet32 cn pm VDD P l=0.18u w=0.42u
M11 VDD m hnet32 VDD P l=0.18u w=0.42u
M12 hnet30 m VSS VSS N l=0.18u w=0.3u
M13 pm c hnet30 VSS N l=0.18u w=0.3u
M14 net53 m VSS VSS N l=0.18u w=1.9u
M15 VDD m net53 VDD P l=0.18u w=2.88u
M16 s net46 VSS VSS N l=0.18u w=0.3u
M17 VDD net46 s VDD P l=0.18u w=0.42u
M18 m pm VSS VSS N l=0.18u w=0.66u
M19 VDD pm m VDD P l=0.18u w=1u
M20 c cn VSS VSS N l=0.18u w=0.54u
M21 VDD cn c VDD P l=0.18u w=0.8u
M22 cn CK VSS VSS N l=0.18u w=0.92u
M23 VDD CK cn VDD P l=0.18u w=1.38u
M24 Q net46 VSS VSS N l=0.18u w=2.4u
M25 VDD net46 Q VDD P l=0.18u w=3.54u
.ends DFFHQX4
*.SCALE meter
.GLOBAL GND VSS VDD

.subckt DFFHQXL Q CK D
M0 net46 cn net53 VDD P l=0.18u w=0.84u
M1 net46 c net53 VSS N l=0.18u w=0.56u
M2 hnet16 c pm VDD P l=0.18u w=0.84u
M3 VDD D hnet16 VDD P l=0.18u w=0.84u
M4 hnet14 D VSS VSS N l=0.18u w=0.56u
M5 pm cn hnet14 VSS N l=0.18u w=0.56u
M6 hnet24 c net46 VDD P l=0.18u w=0.3u
M7 VDD s hnet24 VDD P l=0.18u w=0.3u
M8 hnet22 s VSS VSS N l=0.18u w=0.3u
M9 net46 cn hnet22 VSS N l=0.18u w=0.3u
M10 hnet32 cn pm VDD P l=0.18u w=0.42u
M11 VDD m hnet32 VDD P l=0.18u w=0.42u
M12 hnet30 m VSS VSS N l=0.18u w=0.3u
M13 pm c hnet30 VSS N l=0.18u w=0.3u
M14 net53 m VSS VSS N l=0.18u w=0.3u
M15 VDD m net53 VDD P l=0.18u w=0.46u
M16 s net46 VSS VSS N l=0.18u w=0.3u
M17 VDD net46 s VDD P l=0.18u w=0.42u
M18 m pm VSS VSS N l=0.18u w=0.3u
M19 VDD pm m VDD P l=0.18u w=0.42u
M20 c cn VSS VSS N l=0.18u w=0.3u
M21 VDD cn c VDD P l=0.18u w=0.42u
M22 cn CK VSS VSS N l=0.18u w=0.3u
M23 VDD CK cn VDD P l=0.18u w=0.46u
M24 Q net46 VSS VSS N l=0.18u w=0.42u
M25 VDD net46 Q VDD P l=0.18u w=0.64u
.ends DFFHQXL
*.SCALE meter
.GLOBAL GND VSS VDD

.subckt DFFNRX1 Q QN CKN D RN
M0 VDD net52 hnet17 VDD P l=0.18u w=0.88u
M1 hnet17 net67 s VDD P l=0.18u w=0.88u
M2 s net52 VSS VSS N l=0.18u w=0.44u
M3 s net67 VSS VSS N l=0.18u w=0.44u
M4 VDD net52 hnet23 VDD P l=0.18u w=0.56u
M5 hnet23 pm m VDD P l=0.18u w=0.56u
M6 m net52 VSS VSS N l=0.18u w=0.3u
M7 m pm VSS VSS N l=0.18u w=0.3u
M8 net46 s VSS VSS N l=0.18u w=0.3u
M9 VDD s net46 VDD P l=0.18u w=0.42u
M10 QN s VSS VSS N l=0.18u w=0.6u
M11 VDD s QN VDD P l=0.18u w=0.9u
M12 Q net46 VSS VSS N l=0.18u w=0.6u
M13 VDD net46 Q VDD P l=0.18u w=0.9u
M14 net52 RN VSS VSS N l=0.18u w=0.34u
M15 VDD RN net52 VDD P l=0.18u w=0.52u
M16 c CKN VSS VSS N l=0.18u w=0.42u
M17 VDD CKN c VDD P l=0.18u w=0.6u
M18 cn c VSS VSS N l=0.18u w=0.3u
M19 VDD c cn VDD P l=0.18u w=0.42u
M20 hnet43 cn net67 VDD P l=0.18u w=0.64u
M21 VDD m hnet43 VDD P l=0.18u w=0.64u
M22 hnet41 m VSS VSS N l=0.18u w=0.42u
M23 net67 c hnet41 VSS N l=0.18u w=0.42u
M24 hnet49 c pm VDD P l=0.18u w=0.42u
M25 VDD D hnet49 VDD P l=0.18u w=0.42u
M26 hnet47 D VSS VSS N l=0.18u w=0.3u
M27 pm cn hnet47 VSS N l=0.18u w=0.3u
M28 hnet55 c net67 VDD P l=0.18u w=0.3u
M29 VDD s hnet55 VDD P l=0.18u w=0.3u
M30 hnet53 s VSS VSS N l=0.18u w=0.3u
M31 net67 cn hnet53 VSS N l=0.18u w=0.3u
M32 hnet61 cn pm VDD P l=0.18u w=0.42u
M33 VDD m hnet61 VDD P l=0.18u w=0.42u
M34 hnet59 m VSS VSS N l=0.18u w=0.3u
M35 pm c hnet59 VSS N l=0.18u w=0.3u
.ends DFFNRX1
*.SCALE meter
.GLOBAL GND VSS VDD

.subckt DFFNRX2 Q QN CKN D RN
M0 hnet25 cn net67 VDD P l=0.18u w=0.54u
M1 hnet22 cn net67 VDD P l=0.18u w=0.54u
M2 VDD m hnet25 VDD P l=0.18u w=0.54u
M3 VDD m hnet22 VDD P l=0.18u w=0.54u
M4 hnet17 m VSS VSS N l=0.18u w=0.36u
M5 hnet18 m VSS VSS N l=0.18u w=0.36u
M6 net67 c hnet17 VSS N l=0.18u w=0.36u
M7 net67 c hnet18 VSS N l=0.18u w=0.36u
M8 QN s VSS VSS N l=0.19u w=1.2u
M9 VDD s QN VDD P l=0.18u w=1.8u
M10 Q net54 VSS VSS N l=0.19u w=1.2u
M11 VDD net54 Q VDD P l=0.18u w=1.8u
M12 VDD net56 hnet31 VDD P l=0.18u w=1.52u
M13 hnet31 net67 s VDD P l=0.18u w=1.52u
M14 s net56 VSS VSS N l=0.18u w=0.76u
M15 s net67 VSS VSS N l=0.18u w=0.76u
M16 VDD net56 hnet35 VDD P l=0.18u w=0.56u
M17 hnet35 pm m VDD P l=0.18u w=0.56u
M18 m net56 VSS VSS N l=0.18u w=0.3u
M19 m pm VSS VSS N l=0.18u w=0.3u
M20 net54 s VSS VSS N l=0.18u w=0.48u
M21 VDD s net54 VDD P l=0.18u w=0.72u
M22 net56 RN VSS VSS N l=0.18u w=0.5u
M23 VDD RN net56 VDD P l=0.18u w=0.76u
M24 c CKN VSS VSS N l=0.18u w=0.42u
M25 VDD CKN c VDD P l=0.18u w=0.64u
M26 cn c VSS VSS N l=0.18u w=0.3u
M27 VDD c cn VDD P l=0.18u w=0.44u
M28 hnet49 c pm VDD P l=0.18u w=0.42u
M29 VDD D hnet49 VDD P l=0.18u w=0.42u
M30 hnet47 D VSS VSS N l=0.18u w=0.3u
M31 pm cn hnet47 VSS N l=0.18u w=0.3u
M32 hnet55 c net67 VDD P l=0.18u w=0.3u
M33 VDD s hnet55 VDD P l=0.18u w=0.3u
M34 hnet53 s VSS VSS N l=0.18u w=0.3u
M35 net67 cn hnet53 VSS N l=0.18u w=0.3u
M36 hnet61 cn pm VDD P l=0.18u w=0.42u
M37 VDD m hnet61 VDD P l=0.18u w=0.42u
M38 hnet59 m VSS VSS N l=0.18u w=0.3u
M39 pm c hnet59 VSS N l=0.18u w=0.3u
.ends DFFNRX2
*.SCALE meter
.GLOBAL GND VSS VDD

.subckt DFFNRX4 Q QN CKN D RN
M0 hnet25 cn net67 VDD P l=0.18u w=1u
M1 hnet22 cn net67 VDD P l=0.18u w=1u
M2 VDD m hnet25 VDD P l=0.18u w=1u
M3 VDD m hnet22 VDD P l=0.18u w=1u
M4 hnet17 m VSS VSS N l=0.18u w=0.7u
M5 hnet18 m VSS VSS N l=0.18u w=0.7u
M6 net67 c hnet17 VSS N l=0.18u w=0.7u
M7 net67 c hnet18 VSS N l=0.18u w=0.7u
M8 net44 s VSS VSS N l=0.19u w=0.96u
M9 VDD s net44 VDD P l=0.18u w=1.44u
M10 VDD net56 hnet30 VDD P l=0.18u w=1.4u
M11 hnet30 net67 s VDD P l=0.18u w=1.4u
M12 VDD net56 hnet28 VDD P l=0.18u w=1.4u
M13 hnet28 net67 s VDD P l=0.18u w=1.4u
M14 s net56 VSS VSS N l=0.18u w=1.4u
M15 s net67 VSS VSS N l=0.18u w=1.4u
M16 VDD net56 hnet34 VDD P l=0.18u w=0.92u
M17 hnet34 pm m VDD P l=0.18u w=0.92u
M18 m net56 VSS VSS N l=0.18u w=0.46u
M19 m pm VSS VSS N l=0.18u w=0.46u
M20 QN s VSS VSS N l=0.18u w=2.38u
M21 VDD s QN VDD P l=0.18u w=3.52u
M22 Q net44 VSS VSS N l=0.18u w=2.38u
M23 VDD net44 Q VDD P l=0.18u w=3.52u
M24 net56 RN VSS VSS N l=0.18u w=0.9u
M25 VDD RN net56 VDD P l=0.18u w=1.36u
M26 c CKN VSS VSS N l=0.18u w=0.62u
M27 VDD CKN c VDD P l=0.18u w=0.96u
M28 cn c VSS VSS N l=0.18u w=0.46u
M29 VDD c cn VDD P l=0.18u w=0.66u
M30 hnet50 c pm VDD P l=0.18u w=0.66u
M31 VDD D hnet50 VDD P l=0.18u w=0.66u
M32 hnet48 D VSS VSS N l=0.18u w=0.44u
M33 pm cn hnet48 VSS N l=0.18u w=0.44u
M34 hnet56 c net67 VDD P l=0.18u w=0.3u
M35 VDD s hnet56 VDD P l=0.18u w=0.3u
M36 hnet54 s VSS VSS N l=0.18u w=0.3u
M37 net67 cn hnet54 VSS N l=0.18u w=0.3u
M38 hnet62 cn pm VDD P l=0.18u w=0.42u
M39 VDD m hnet62 VDD P l=0.18u w=0.42u
M40 hnet60 m VSS VSS N l=0.18u w=0.3u
M41 pm c hnet60 VSS N l=0.18u w=0.3u
.ends DFFNRX4
*.SCALE meter
.GLOBAL GND VSS VDD

.subckt DFFNRXL Q QN CKN D RN
M0 VDD net52 hnet17 VDD P l=0.18u w=0.56u
M1 hnet17 net67 s VDD P l=0.18u w=0.56u
M2 s net52 VSS VSS N l=0.18u w=0.3u
M3 s net67 VSS VSS N l=0.18u w=0.3u
M4 VDD net52 hnet23 VDD P l=0.18u w=0.56u
M5 hnet23 pm m VDD P l=0.18u w=0.56u
M6 m net52 VSS VSS N l=0.18u w=0.3u
M7 m pm VSS VSS N l=0.18u w=0.3u
M8 net46 s VSS VSS N l=0.18u w=0.3u
M9 VDD s net46 VDD P l=0.18u w=0.42u
M10 QN s VSS VSS N l=0.18u w=0.42u
M11 VDD s QN VDD P l=0.18u w=0.64u
M12 Q net46 VSS VSS N l=0.18u w=0.42u
M13 VDD net46 Q VDD P l=0.18u w=0.64u
M14 net52 RN VSS VSS N l=0.18u w=0.3u
M15 VDD RN net52 VDD P l=0.18u w=0.42u
M16 c CKN VSS VSS N l=0.18u w=0.3u
M17 VDD CKN c VDD P l=0.18u w=0.42u
M18 cn c VSS VSS N l=0.18u w=0.3u
M19 VDD c cn VDD P l=0.18u w=0.42u
M20 hnet43 cn net67 VDD P l=0.18u w=0.84u
M21 VDD m hnet43 VDD P l=0.18u w=0.84u
M22 hnet41 m VSS VSS N l=0.18u w=0.56u
M23 net67 c hnet41 VSS N l=0.18u w=0.56u
M24 hnet49 c pm VDD P l=0.18u w=0.84u
M25 VDD D hnet49 VDD P l=0.18u w=0.84u
M26 hnet47 D VSS VSS N l=0.18u w=0.56u
M27 pm cn hnet47 VSS N l=0.18u w=0.56u
M28 hnet55 c net67 VDD P l=0.18u w=0.3u
M29 VDD s hnet55 VDD P l=0.18u w=0.3u
M30 hnet53 s VSS VSS N l=0.18u w=0.3u
M31 net67 cn hnet53 VSS N l=0.18u w=0.3u
M32 hnet61 cn pm VDD P l=0.18u w=0.42u
M33 VDD m hnet61 VDD P l=0.18u w=0.42u
M34 hnet59 m VSS VSS N l=0.18u w=0.3u
M35 pm c hnet59 VSS N l=0.18u w=0.3u
.ends DFFNRXL
*.SCALE meter
.GLOBAL GND VSS VDD

.subckt DFFNSRX1 Q QN CKN D RN SN
M0 VDD net103 hnet25 VDD P l=0.18u w=0.88u
M1 hnet25 net116 s VDD P l=0.18u w=0.88u
M2 s net103 net73 VSS N l=0.18u w=0.58u
M3 s net116 net73 VSS N l=0.18u w=0.58u
M4 net73 SN VSS VSS N l=0.18u w=0.58u
M5 m net103 net82 VSS N l=0.18u w=0.3u
M6 m pm net82 VSS N l=0.18u w=0.3u
M7 net82 SN VSS VSS N l=0.18u w=0.3u
M8 s SN VDD VDD P l=0.18u w=0.66u
M9 m SN VDD VDD P l=0.18u w=0.3u
M10 m pm net90 VDD P l=0.18u w=0.4u
M11 net90 net103 VDD VDD P l=0.18u w=0.4u
M12 cn c VSS VSS N l=0.18u w=0.3u
M13 VDD c cn VDD P l=0.18u w=0.46u
M14 net97 s VSS VSS N l=0.18u w=0.3u
M15 VDD s net97 VDD P l=0.18u w=0.42u
M16 Q net97 VSS VSS N l=0.18u w=0.6u
M17 VDD net97 Q VDD P l=0.18u w=0.9u
M18 QN s VSS VSS N l=0.18u w=0.6u
M19 VDD s QN VDD P l=0.18u w=0.9u
M20 net103 RN VSS VSS N l=0.18u w=0.34u
M21 VDD RN net103 VDD P l=0.18u w=0.52u
M22 c CKN VSS VSS N l=0.18u w=0.4u
M23 VDD CKN c VDD P l=0.18u w=0.6u
M24 hnet41 cn net116 VDD P l=0.18u w=0.68u
M25 VDD m hnet41 VDD P l=0.18u w=0.68u
M26 hnet39 m VSS VSS N l=0.18u w=0.46u
M27 net116 c hnet39 VSS N l=0.18u w=0.46u
M28 hnet47 c pm VDD P l=0.18u w=0.46u
M29 VDD D hnet47 VDD P l=0.18u w=0.46u
M30 hnet45 D VSS VSS N l=0.18u w=0.3u
M31 pm cn hnet45 VSS N l=0.18u w=0.3u
M32 hnet53 c net116 VDD P l=0.18u w=0.3u
M33 VDD s hnet53 VDD P l=0.18u w=0.3u
M34 hnet51 s VSS VSS N l=0.18u w=0.3u
M35 net116 cn hnet51 VSS N l=0.18u w=0.3u
M36 hnet59 cn pm VDD P l=0.18u w=0.46u
M37 VDD m hnet59 VDD P l=0.18u w=0.46u
M38 hnet57 m VSS VSS N l=0.18u w=0.3u
M39 pm c hnet57 VSS N l=0.18u w=0.3u
.ends DFFNSRX1
*.SCALE meter
.GLOBAL GND VSS VDD

.subckt DFFNSRX2 Q QN CKN D RN SN
M0 VDD net103 hnet25 VDD P l=0.18u w=1.52u
M1 hnet25 net116 s VDD P l=0.18u w=1.52u
M2 s net103 net73 VSS N l=0.18u w=1u
M3 s net116 net73 VSS N l=0.18u w=1u
M4 net73 SN VSS VSS N l=0.18u w=1u
M5 m net103 net82 VSS N l=0.18u w=0.38u
M6 m pm net82 VSS N l=0.18u w=0.38u
M7 net82 SN VSS VSS N l=0.18u w=0.38u
M8 s SN VDD VDD P l=0.18u w=1.14u
M9 m SN VDD VDD P l=0.18u w=0.44u
M10 m pm net90 VDD P l=0.18u w=0.58u
M11 net90 net103 VDD VDD P l=0.18u w=0.58u
M12 cn c VSS VSS N l=0.18u w=0.32u
M13 VDD c cn VDD P l=0.18u w=0.48u
M14 net97 s VSS VSS N l=0.18u w=0.44u
M15 VDD s net97 VDD P l=0.18u w=0.72u
M16 Q net97 VSS VSS N l=0.18u w=1.2u
M17 VDD net97 Q VDD P l=0.18u w=1.74u
M18 QN s VSS VSS N l=0.18u w=1.2u
M19 VDD s QN VDD P l=0.18u w=1.74u
M20 net103 RN VSS VSS N l=0.18u w=0.56u
M21 VDD RN net103 VDD P l=0.18u w=0.84u
M22 c CKN VSS VSS N l=0.18u w=0.44u
M23 VDD CKN c VDD P l=0.18u w=0.64u
M24 hnet41 cn net116 VDD P l=0.18u w=1.18u
M25 VDD m hnet41 VDD P l=0.18u w=1.18u
M26 hnet39 m VSS VSS N l=0.18u w=0.8u
M27 net116 c hnet39 VSS N l=0.18u w=0.8u
M28 hnet47 c pm VDD P l=0.18u w=0.46u
M29 VDD D hnet47 VDD P l=0.18u w=0.46u
M30 hnet45 D VSS VSS N l=0.18u w=0.3u
M31 pm cn hnet45 VSS N l=0.18u w=0.3u
M32 hnet53 c net116 VDD P l=0.18u w=0.3u
M33 VDD s hnet53 VDD P l=0.18u w=0.3u
M34 hnet51 s VSS VSS N l=0.18u w=0.3u
M35 net116 cn hnet51 VSS N l=0.18u w=0.3u
M36 hnet59 cn pm VDD P l=0.18u w=0.46u
M37 VDD m hnet59 VDD P l=0.18u w=0.46u
M38 hnet57 m VSS VSS N l=0.18u w=0.3u
M39 pm c hnet57 VSS N l=0.18u w=0.3u
.ends DFFNSRX2
*.SCALE meter
.GLOBAL GND VSS VDD

.subckt DFFNSRX4 Q QN CKN D RN SN
M0 hnet29 cn net116 VDD P l=0.18u w=1.14u
M1 hnet27 cn net116 VDD P l=0.18u w=1.14u
M2 VDD m hnet29 VDD P l=0.18u w=1.14u
M3 VDD m hnet27 VDD P l=0.18u w=1.14u
M4 hnet23 m VSS VSS N l=0.18u w=0.76u
M5 hnet24 m VSS VSS N l=0.18u w=0.76u
M6 net116 c hnet23 VSS N l=0.18u w=0.76u
M7 net116 c hnet24 VSS N l=0.18u w=0.76u
M8 VDD net107 hnet34 VDD P l=0.18u w=1.42u
M9 hnet34 net116 s VDD P l=0.18u w=1.42u
M10 VDD net107 hnet31 VDD P l=0.18u w=1.42u
M11 hnet31 net116 s VDD P l=0.18u w=1.42u
M12 s net107 net77 VSS N l=0.18u w=1.88u
M13 s net116 net77 VSS N l=0.18u w=1.88u
M14 net77 SN VSS VSS N l=0.18u w=1.88u
M15 m net107 net86 VSS N l=0.18u w=0.64u
M16 m pm net86 VSS N l=0.18u w=0.64u
M17 net86 SN VSS VSS N l=0.18u w=0.66u
M18 s SN VDD VDD P l=0.18u w=2.14u
M19 m SN VDD VDD P l=0.18u w=0.76u
M20 m pm net94 VDD P l=0.18u w=1.02u
M21 net94 net107 VDD VDD P l=0.18u w=1.02u
M22 cn c VSS VSS N l=0.18u w=0.5u
M23 VDD c cn VDD P l=0.18u w=0.76u
M24 net101 s VSS VSS N l=0.18u w=0.96u
M25 VDD s net101 VDD P l=0.18u w=1.44u
M26 Q net101 VSS VSS N l=0.18u w=2.4u
M27 VDD net101 Q VDD P l=0.18u w=3.52u
M28 QN s VSS VSS N l=0.18u w=2.4u
M29 VDD s QN VDD P l=0.18u w=3.52u
M30 net107 RN VSS VSS N l=0.18u w=0.94u
M31 VDD RN net107 VDD P l=0.18u w=1.52u
M32 c CKN VSS VSS N l=0.18u w=0.68u
M33 VDD CKN c VDD P l=0.18u w=1.02u
M34 hnet50 c pm VDD P l=0.18u w=0.8u
M35 VDD D hnet50 VDD P l=0.18u w=0.8u
M36 hnet48 D VSS VSS N l=0.18u w=0.54u
M37 pm cn hnet48 VSS N l=0.18u w=0.54u
M38 hnet56 c net116 VDD P l=0.18u w=0.3u
M39 VDD s hnet56 VDD P l=0.18u w=0.3u
M40 hnet54 s VSS VSS N l=0.18u w=0.3u
M41 net116 cn hnet54 VSS N l=0.18u w=0.3u
M42 hnet62 cn pm VDD P l=0.18u w=0.46u
M43 VDD m hnet62 VDD P l=0.18u w=0.46u
M44 hnet60 m VSS VSS N l=0.18u w=0.3u
M45 pm c hnet60 VSS N l=0.18u w=0.3u
.ends DFFNSRX4
*.SCALE meter
.GLOBAL GND VSS VDD

.subckt DFFNSRXL Q QN CKN D RN SN
M0 VDD D hnet26 VDD P l=0.18u w=0.84u
M1 hnet26 c pm VDD P l=0.18u w=0.84u
M2 VDD net118 hnet30 VDD P l=0.18u w=0.56u
M3 hnet30 net127 s VDD P l=0.18u w=0.56u
M4 net76 D VSS VSS N l=0.18u w=0.56u
M5 pm cn net76 VSS N l=0.18u w=0.54u
M6 s net118 net88 VSS N l=0.18u w=0.36u
M7 s net127 net88 VSS N l=0.18u w=0.36u
M8 net88 SN VSS VSS N l=0.18u w=0.36u
M9 m net118 net97 VSS N l=0.18u w=0.36u
M10 m pm net97 VSS N l=0.18u w=0.36u
M11 net97 SN VSS VSS N l=0.18u w=0.36u
M12 s SN VDD VDD P l=0.18u w=0.46u
M13 m SN VDD VDD P l=0.18u w=0.42u
M14 m pm net105 VDD P l=0.18u w=0.56u
M15 net105 net118 VDD VDD P l=0.18u w=0.56u
M16 cn c VSS VSS N l=0.18u w=0.3u
M17 VDD c cn VDD P l=0.18u w=0.46u
M18 net112 s VSS VSS N l=0.18u w=0.3u
M19 VDD s net112 VDD P l=0.18u w=0.42u
M20 Q net112 VSS VSS N l=0.18u w=0.46u
M21 VDD net112 Q VDD P l=0.18u w=0.64u
M22 QN s VSS VSS N l=0.18u w=0.42u
M23 VDD s QN VDD P l=0.18u w=0.64u
M24 net118 RN VSS VSS N l=0.18u w=0.3u
M25 VDD RN net118 VDD P l=0.18u w=0.46u
M26 c CKN VSS VSS N l=0.18u w=0.3u
M27 VDD CKN c VDD P l=0.18u w=0.46u
M28 hnet46 cn net127 VDD P l=0.18u w=0.84u
M29 VDD m hnet46 VDD P l=0.18u w=0.84u
M30 hnet44 m VSS VSS N l=0.18u w=0.56u
M31 net127 c hnet44 VSS N l=0.18u w=0.56u
M32 hnet52 c net127 VDD P l=0.18u w=0.3u
M33 VDD s hnet52 VDD P l=0.18u w=0.3u
M34 hnet50 s VSS VSS N l=0.18u w=0.3u
M35 net127 cn hnet50 VSS N l=0.18u w=0.3u
M36 hnet58 cn pm VDD P l=0.18u w=0.42u
M37 VDD m hnet58 VDD P l=0.18u w=0.42u
M38 hnet56 m VSS VSS N l=0.18u w=0.3u
M39 pm c hnet56 VSS N l=0.18u w=0.3u
.ends DFFNSRXL
*.SCALE meter
.GLOBAL GND VSS VDD

.subckt DFFNSX1 Q QN CKN D SN
M0 VDD SN s VDD P l=0.18u w=0.66u
M1 VDD net65 s VDD P l=0.18u w=0.66u
M2 hnet19 SN VSS VSS N l=0.18u w=0.58u
M3 s net65 hnet19 VSS N l=0.18u w=0.58u
M4 VDD SN m VDD P l=0.18u w=0.32u
M5 VDD pm m VDD P l=0.18u w=0.32u
M6 hnet25 SN VSS VSS N l=0.18u w=0.3u
M7 m pm hnet25 VSS N l=0.18u w=0.3u
M8 Q net50 VSS VSS N l=0.18u w=0.6u
M9 VDD net50 Q VDD P l=0.18u w=0.9u
M10 QN s VSS VSS N l=0.18u w=0.6u
M11 VDD s QN VDD P l=0.18u w=0.9u
M12 net50 s VSS VSS N l=0.18u w=0.3u
M13 VDD s net50 VDD P l=0.18u w=0.42u
M14 cn c VSS VSS N l=0.18u w=0.3u
M15 VDD c cn VDD P l=0.18u w=0.42u
M16 c CKN VSS VSS N l=0.18u w=0.4u
M17 VDD CKN c VDD P l=0.18u w=0.6u
M18 hnet40 cn net65 VDD P l=0.18u w=0.6u
M19 VDD m hnet40 VDD P l=0.18u w=0.6u
M20 hnet38 m VSS VSS N l=0.18u w=0.4u
M21 net65 c hnet38 VSS N l=0.18u w=0.4u
M22 hnet46 c pm VDD P l=0.18u w=0.42u
M23 VDD D hnet46 VDD P l=0.18u w=0.42u
M24 hnet44 D VSS VSS N l=0.18u w=0.3u
M25 pm cn hnet44 VSS N l=0.18u w=0.3u
M26 hnet52 c net65 VDD P l=0.18u w=0.3u
M27 VDD s hnet52 VDD P l=0.18u w=0.3u
M28 hnet50 s VSS VSS N l=0.18u w=0.3u
M29 net65 cn hnet50 VSS N l=0.18u w=0.3u
M30 hnet58 cn pm VDD P l=0.18u w=0.42u
M31 VDD m hnet58 VDD P l=0.18u w=0.42u
M32 hnet56 m VSS VSS N l=0.18u w=0.3u
M33 pm c hnet56 VSS N l=0.18u w=0.3u
.ends DFFNSX1
*.SCALE meter
.GLOBAL GND VSS VDD

.subckt DFFNSX2 Q QN CKN D SN
M0 VDD SN s VDD P l=0.18u w=1.14u
M1 VDD net65 s VDD P l=0.18u w=1.14u
M2 hnet19 SN VSS VSS N l=0.18u w=1u
M3 s net65 hnet19 VSS N l=0.18u w=1u
M4 VDD SN m VDD P l=0.18u w=0.4u
M5 VDD pm m VDD P l=0.18u w=0.4u
M6 hnet25 SN VSS VSS N l=0.18u w=0.36u
M7 m pm hnet25 VSS N l=0.18u w=0.36u
M8 Q net50 VSS VSS N l=0.18u w=1.2u
M9 VDD net50 Q VDD P l=0.18u w=1.74u
M10 QN s VSS VSS N l=0.18u w=1.2u
M11 VDD s QN VDD P l=0.18u w=1.74u
M12 net50 s VSS VSS N l=0.18u w=0.48u
M13 VDD s net50 VDD P l=0.18u w=0.72u
M14 cn c VSS VSS N l=0.18u w=0.3u
M15 VDD c cn VDD P l=0.18u w=0.44u
M16 c CKN VSS VSS N l=0.18u w=0.42u
M17 VDD CKN c VDD P l=0.18u w=0.64u
M18 hnet40 cn net65 VDD P l=0.18u w=1.02u
M19 VDD m hnet40 VDD P l=0.18u w=1.02u
M20 hnet38 m VSS VSS N l=0.18u w=0.68u
M21 net65 c hnet38 VSS N l=0.18u w=0.68u
M22 hnet46 c pm VDD P l=0.18u w=0.42u
M23 VDD D hnet46 VDD P l=0.18u w=0.42u
M24 hnet44 D VSS VSS N l=0.18u w=0.3u
M25 pm cn hnet44 VSS N l=0.18u w=0.3u
M26 hnet52 c net65 VDD P l=0.18u w=0.3u
M27 VDD s hnet52 VDD P l=0.18u w=0.3u
M28 hnet50 s VSS VSS N l=0.18u w=0.3u
M29 net65 cn hnet50 VSS N l=0.18u w=0.3u
M30 hnet58 cn pm VDD P l=0.18u w=0.42u
M31 VDD m hnet58 VDD P l=0.18u w=0.42u
M32 hnet56 m VSS VSS N l=0.18u w=0.3u
M33 pm c hnet56 VSS N l=0.18u w=0.3u
.ends DFFNSX2
*.SCALE meter
.GLOBAL GND VSS VDD

.subckt DFFNSX4 Q QN CKN D SN
M0 hnet24 cn net65 VDD P l=0.18u w=0.9u
M1 hnet21 cn net65 VDD P l=0.18u w=0.9u
M2 VDD m hnet24 VDD P l=0.18u w=0.9u
M3 VDD m hnet21 VDD P l=0.18u w=0.9u
M4 hnet16 m VSS VSS N l=0.18u w=0.6u
M5 hnet17 m VSS VSS N l=0.18u w=0.6u
M6 net65 c hnet16 VSS N l=0.18u w=0.6u
M7 net65 c hnet17 VSS N l=0.18u w=0.6u
M8 VDD SN s VDD P l=0.18u w=2.12u
M9 VDD net65 s VDD P l=0.18u w=2.12u
M10 hnet29 SN VSS VSS N l=0.18u w=0.94u
M11 s net65 hnet29 VSS N l=0.18u w=0.94u
M12 hnet25 SN VSS VSS N l=0.18u w=0.94u
M13 s net65 hnet25 VSS N l=0.18u w=0.94u
M14 VDD SN m VDD P l=0.18u w=0.62u
M15 VDD pm m VDD P l=0.18u w=0.62u
M16 hnet33 SN VSS VSS N l=0.18u w=0.54u
M17 m pm hnet33 VSS N l=0.18u w=0.54u
M18 Q net54 VSS VSS N l=0.18u w=2.4u
M19 VDD net54 Q VDD P l=0.18u w=3.54u
M20 QN s VSS VSS N l=0.18u w=2.4u
M21 VDD s QN VDD P l=0.18u w=3.54u
M22 net54 s VSS VSS N l=0.18u w=0.96u
M23 VDD s net54 VDD P l=0.18u w=1.44u
M24 cn c VSS VSS N l=0.18u w=0.4u
M25 VDD c cn VDD P l=0.18u w=0.6u
M26 c CKN VSS VSS N l=0.18u w=0.56u
M27 VDD CKN c VDD P l=0.18u w=0.84u
M28 hnet47 c pm VDD P l=0.18u w=0.54u
M29 VDD D hnet47 VDD P l=0.18u w=0.54u
M30 hnet45 D VSS VSS N l=0.18u w=0.36u
M31 pm cn hnet45 VSS N l=0.18u w=0.36u
M32 hnet53 c net65 VDD P l=0.18u w=0.3u
M33 VDD s hnet53 VDD P l=0.18u w=0.3u
M34 hnet51 s VSS VSS N l=0.18u w=0.3u
M35 net65 cn hnet51 VSS N l=0.18u w=0.3u
M36 hnet59 cn pm VDD P l=0.18u w=0.42u
M37 VDD m hnet59 VDD P l=0.18u w=0.42u
M38 hnet57 m VSS VSS N l=0.18u w=0.3u
M39 pm c hnet57 VSS N l=0.18u w=0.3u
.ends DFFNSX4
*.SCALE meter
.GLOBAL GND VSS VDD

.subckt DFFNSXL Q QN CKN D SN
M0 VDD SN s VDD P l=0.18u w=0.42u
M1 VDD net65 s VDD P l=0.18u w=0.42u
M2 hnet19 SN VSS VSS N l=0.18u w=0.36u
M3 s net65 hnet19 VSS N l=0.18u w=0.36u
M4 VDD SN m VDD P l=0.18u w=0.42u
M5 VDD pm m VDD P l=0.18u w=0.42u
M6 hnet25 SN VSS VSS N l=0.18u w=0.36u
M7 m pm hnet25 VSS N l=0.18u w=0.36u
M8 Q net50 VSS VSS N l=0.18u w=0.42u
M9 VDD net50 Q VDD P l=0.18u w=0.64u
M10 QN s VSS VSS N l=0.18u w=0.42u
M11 VDD s QN VDD P l=0.18u w=0.64u
M12 net50 s VSS VSS N l=0.18u w=0.3u
M13 VDD s net50 VDD P l=0.18u w=0.42u
M14 cn c VSS VSS N l=0.18u w=0.3u
M15 VDD c cn VDD P l=0.18u w=0.42u
M16 c CKN VSS VSS N l=0.18u w=0.3u
M17 VDD CKN c VDD P l=0.18u w=0.42u
M18 hnet40 cn net65 VDD P l=0.18u w=0.84u
M19 VDD m hnet40 VDD P l=0.18u w=0.84u
M20 hnet38 m VSS VSS N l=0.18u w=0.56u
M21 net65 c hnet38 VSS N l=0.18u w=0.56u
M22 hnet46 c pm VDD P l=0.18u w=0.84u
M23 VDD D hnet46 VDD P l=0.18u w=0.84u
M24 hnet44 D VSS VSS N l=0.18u w=0.56u
M25 pm cn hnet44 VSS N l=0.18u w=0.56u
M26 hnet52 c net65 VDD P l=0.18u w=0.3u
M27 VDD s hnet52 VDD P l=0.18u w=0.3u
M28 hnet50 s VSS VSS N l=0.18u w=0.3u
M29 net65 cn hnet50 VSS N l=0.18u w=0.3u
M30 hnet58 cn pm VDD P l=0.18u w=0.42u
M31 VDD m hnet58 VDD P l=0.18u w=0.42u
M32 hnet56 m VSS VSS N l=0.18u w=0.3u
M33 pm c hnet56 VSS N l=0.18u w=0.3u
.ends DFFNSXL
*.SCALE meter
.GLOBAL GND VSS VDD

.subckt DFFNX1 Q QN CKN D
M0 hnet16 cn net43 VDD P l=0.18u w=1.12u
M1 VDD m hnet16 VDD P l=0.18u w=1.12u
M2 hnet14 m VSS VSS N l=0.18u w=0.74u
M3 net43 c hnet14 VSS N l=0.18u w=0.74u
M4 hnet24 c pm VDD P l=0.18u w=0.42u
M5 VDD D hnet24 VDD P l=0.18u w=0.43u
M6 hnet22 D VSS VSS N l=0.18u w=0.3u
M7 pm cn hnet22 VSS N l=0.18u w=0.3u
M8 hnet32 c net43 VDD P l=0.18u w=0.3u
M9 VDD s hnet32 VDD P l=0.18u w=0.3u
M10 hnet30 s VSS VSS N l=0.18u w=0.3u
M11 net43 cn hnet30 VSS N l=0.18u w=0.3u
M12 hnet40 cn pm VDD P l=0.18u w=0.42u
M13 VDD m hnet40 VDD P l=0.18u w=0.42u
M14 hnet38 m VSS VSS N l=0.18u w=0.3u
M15 pm c hnet38 VSS N l=0.18u w=0.3u
M16 s net43 VSS VSS N l=0.18u w=0.32u
M17 VDD net43 s VDD P l=0.18u w=0.48u
M18 m pm VSS VSS N l=0.18u w=0.3u
M19 VDD pm m VDD P l=0.18u w=0.42u
M20 QN s VSS VSS N l=0.18u w=0.6u
M21 VDD s QN VDD P l=0.18u w=0.9u
M22 cn c VSS VSS N l=0.18u w=0.3u
M23 VDD c cn VDD P l=0.18u w=0.44u
M24 c CKN VSS VSS N l=0.18u w=0.42u
M25 VDD CKN c VDD P l=0.18u w=0.64u
M26 Q net43 VSS VSS N l=0.18u w=0.58u
M27 VDD net43 Q VDD P l=0.18u w=0.9u
.ends DFFNX1
*.SCALE meter
.GLOBAL GND VSS VDD

.subckt DFFNX2 Q QN CKN D
M0 hnet22 cn net43 VDD P l=0.18u w=1.06u
M1 hnet19 cn net43 VDD P l=0.18u w=1.06u
M2 VDD m hnet22 VDD P l=0.18u w=1.06u
M3 VDD m hnet19 VDD P l=0.18u w=1.06u
M4 hnet14 m VSS VSS N l=0.18u w=0.7u
M5 hnet15 m VSS VSS N l=0.18u w=0.7u
M6 net43 c hnet14 VSS N l=0.18u w=0.7u
M7 net43 c hnet15 VSS N l=0.18u w=0.7u
M8 hnet26 c pm VDD P l=0.18u w=0.54u
M9 VDD D hnet26 VDD P l=0.18u w=0.54u
M10 hnet24 D VSS VSS N l=0.18u w=0.36u
M11 pm cn hnet24 VSS N l=0.18u w=0.36u
M12 hnet32 c net43 VDD P l=0.18u w=0.3u
M13 VDD s hnet32 VDD P l=0.18u w=0.3u
M14 hnet30 s VSS VSS N l=0.18u w=0.3u
M15 net43 cn hnet30 VSS N l=0.18u w=0.3u
M16 hnet38 cn pm VDD P l=0.18u w=0.42u
M17 VDD m hnet38 VDD P l=0.18u w=0.42u
M18 hnet36 m VSS VSS N l=0.18u w=0.3u
M19 pm c hnet36 VSS N l=0.18u w=0.3u
M20 s net43 VSS VSS N l=0.18u w=0.56u
M21 VDD net43 s VDD P l=0.18u w=0.84u
M22 m pm VSS VSS N l=0.18u w=0.46u
M23 VDD pm m VDD P l=0.18u w=0.68u
M24 QN s VSS VSS N l=0.18u w=1.2u
M25 VDD s QN VDD P l=0.18u w=1.8u
M26 cn c VSS VSS N l=0.18u w=0.44u
M27 VDD c cn VDD P l=0.18u w=0.66u
M28 c CKN VSS VSS N l=0.18u w=0.62u
M29 VDD CKN c VDD P l=0.18u w=0.92u
M30 Q net43 VSS VSS N l=0.18u w=1.16u
M31 VDD net43 Q VDD P l=0.18u w=1.8u
.ends DFFNX2
*.SCALE meter
.GLOBAL GND VSS VDD

.subckt DFFNX4 Q QN CKN D
M0 hnet16 cn net43 VDD P l=0.18u w=1.38u
M1 hnet18 cn net43 VDD P l=0.18u w=1.38u
M2 hnet15 cn net43 VDD P l=0.18u w=1.38u
M3 VDD m hnet16 VDD P l=0.18u w=1.38u
M4 VDD m hnet18 VDD P l=0.18u w=1.38u
M5 VDD m hnet15 VDD P l=0.18u w=1.38u
M6 hnet14 m VSS VSS N l=0.18u w=0.92u
M7 hnet17 m VSS VSS N l=0.18u w=0.92u
M8 hnet22 m VSS VSS N l=0.18u w=0.92u
M9 net43 c hnet14 VSS N l=0.18u w=0.92u
M10 net43 c hnet17 VSS N l=0.18u w=0.92u
M11 net43 c hnet22 VSS N l=0.18u w=0.92u
M12 hnet28 c pm VDD P l=0.18u w=0.78u
M13 VDD D hnet28 VDD P l=0.18u w=0.78u
M14 hnet26 D VSS VSS N l=0.18u w=0.52u
M15 pm cn hnet26 VSS N l=0.18u w=0.52u
M16 hnet34 c net43 VDD P l=0.18u w=0.3u
M17 VDD s hnet34 VDD P l=0.18u w=0.3u
M18 hnet32 s VSS VSS N l=0.18u w=0.3u
M19 net43 cn hnet32 VSS N l=0.18u w=0.3u
M20 hnet40 cn pm VDD P l=0.18u w=0.42u
M21 VDD m hnet40 VDD P l=0.18u w=0.42u
M22 hnet38 m VSS VSS N l=0.18u w=0.3u
M23 pm c hnet38 VSS N l=0.18u w=0.3u
M24 s net43 VSS VSS N l=0.18u w=1.04u
M25 VDD net43 s VDD P l=0.18u w=1.56u
M26 m pm VSS VSS N l=0.18u w=0.84u
M27 VDD pm m VDD P l=0.18u w=1.26u
M28 QN s VSS VSS N l=0.18u w=2.4u
M29 VDD s QN VDD P l=0.18u w=3.38u
M30 cn c VSS VSS N l=0.18u w=0.76u
M31 VDD c cn VDD P l=0.18u w=1.14u
M32 c CKN VSS VSS N l=0.18u w=1.06u
M33 VDD CKN c VDD P l=0.18u w=1.6u
M34 Q net43 VSS VSS N l=0.18u w=2.4u
M35 VDD net43 Q VDD P l=0.18u w=3.38u
.ends DFFNX4
*.SCALE meter
.GLOBAL GND VSS VDD

.subckt DFFNXL Q QN CKN D
M0 hnet16 cn net43 VDD P l=0.18u w=0.84u
M1 VDD m hnet16 VDD P l=0.18u w=0.84u
M2 hnet14 m VSS VSS N l=0.18u w=0.56u
M3 net43 c hnet14 VSS N l=0.18u w=0.56u
M4 hnet24 c pm VDD P l=0.18u w=0.84u
M5 VDD D hnet24 VDD P l=0.18u w=0.84u
M6 hnet22 D VSS VSS N l=0.18u w=0.56u
M7 pm cn hnet22 VSS N l=0.18u w=0.56u
M8 hnet32 c net43 VDD P l=0.18u w=0.3u
M9 VDD s hnet32 VDD P l=0.18u w=0.3u
M10 hnet30 s VSS VSS N l=0.18u w=0.3u
M11 net43 cn hnet30 VSS N l=0.18u w=0.3u
M12 hnet40 cn pm VDD P l=0.18u w=0.42u
M13 VDD m hnet40 VDD P l=0.18u w=0.42u
M14 hnet38 m VSS VSS N l=0.18u w=0.3u
M15 pm c hnet38 VSS N l=0.18u w=0.3u
M16 s net43 VSS VSS N l=0.18u w=0.3u
M17 VDD net43 s VDD P l=0.18u w=0.42u
M18 m pm VSS VSS N l=0.18u w=0.3u
M19 VDD pm m VDD P l=0.18u w=0.42u
M20 QN s VSS VSS N l=0.18u w=0.42u
M21 VDD s QN VDD P l=0.18u w=0.64u
M22 cn c VSS VSS N l=0.18u w=0.3u
M23 VDD c cn VDD P l=0.18u w=0.42u
M24 c CKN VSS VSS N l=0.18u w=0.3u
M25 VDD CKN c VDD P l=0.18u w=0.42u
M26 Q net43 VSS VSS N l=0.18u w=0.42u
M27 VDD net43 Q VDD P l=0.18u w=0.64u
.ends DFFNXL
*.SCALE meter
.GLOBAL GND VSS VDD

.subckt DFFRHQX1 Q CK D RN
M0 net68 cn net55 VDD P l=0.18u w=1.26u
M1 net68 c net55 VSS N l=0.18u w=0.84u
M2 VDD net57 hnet16 VDD P l=0.18u w=0.64u
M3 hnet16 pm m VDD P l=0.18u w=0.64u
M4 m net57 VSS VSS N l=0.18u w=0.32u
M5 m pm VSS VSS N l=0.18u w=0.32u
M6 VDD net57 hnet22 VDD P l=0.18u w=1.2u
M7 hnet22 net68 Q VDD P l=0.18u w=1.2u
M8 Q net57 VSS VSS N l=0.18u w=0.6u
M9 Q net68 VSS VSS N l=0.18u w=0.6u
M10 VDD net57 hnet28 VDD P l=0.18u w=0.56u
M11 hnet28 net68 s VDD P l=0.18u w=0.56u
M12 s net57 VSS VSS N l=0.18u w=0.3u
M13 s net68 VSS VSS N l=0.18u w=0.3u
M14 net55 m VSS VSS N l=0.18u w=0.84u
M15 VDD m net55 VDD P l=0.18u w=1.26u
M16 net57 RN VSS VSS N l=0.18u w=0.58u
M17 VDD RN net57 VDD P l=0.18u w=0.88u
M18 cn CK VSS VSS N l=0.18u w=0.48u
M19 VDD CK cn VDD P l=0.18u w=0.72u
M20 c cn VSS VSS N l=0.18u w=0.3u
M21 VDD cn c VDD P l=0.18u w=0.44u
M22 hnet44 c pm VDD P l=0.18u w=0.44u
M23 VDD D hnet44 VDD P l=0.18u w=0.44u
M24 hnet42 D VSS VSS N l=0.18u w=0.3u
M25 pm cn hnet42 VSS N l=0.18u w=0.3u
M26 hnet50 c net68 VDD P l=0.18u w=0.3u
M27 VDD s hnet50 VDD P l=0.18u w=0.3u
M28 hnet48 s VSS VSS N l=0.18u w=0.3u
M29 net68 cn hnet48 VSS N l=0.18u w=0.3u
M30 hnet56 cn pm VDD P l=0.18u w=0.42u
M31 VDD m hnet56 VDD P l=0.18u w=0.42u
M32 hnet54 m VSS VSS N l=0.18u w=0.3u
M33 pm c hnet54 VSS N l=0.18u w=0.3u
.ends DFFRHQX1
*.SCALE meter
.GLOBAL GND VSS VDD

.subckt DFFRHQX2 Q CK D RN
M0 net68 cn net55 VDD P l=0.18u w=2.1u
M1 net68 c net55 VSS N l=0.18u w=1.4u
M2 VDD net57 hnet17 VDD P l=0.18u w=1.2u
M3 hnet17 net68 Q VDD P l=0.18u w=1.2u
M4 VDD net57 hnet15 VDD P l=0.18u w=1.2u
M5 hnet15 net68 Q VDD P l=0.18u w=1.2u
M6 Q net57 VSS VSS N l=0.18u w=1.2u
M7 Q net68 VSS VSS N l=0.18u w=1.2u
M8 VDD net57 hnet23 VDD P l=0.18u w=0.92u
M9 hnet23 pm m VDD P l=0.18u w=0.92u
M10 m net57 VSS VSS N l=0.18u w=0.46u
M11 m pm VSS VSS N l=0.18u w=0.46u
M12 VDD net57 hnet27 VDD P l=0.18u w=0.56u
M13 hnet27 net68 s VDD P l=0.18u w=0.56u
M14 s net57 VSS VSS N l=0.18u w=0.3u
M15 s net68 VSS VSS N l=0.18u w=0.3u
M16 net55 m VSS VSS N l=0.18u w=1.4u
M17 VDD m net55 VDD P l=0.18u w=2.1u
M18 net57 RN VSS VSS N l=0.18u w=0.92u
M19 VDD RN net57 VDD P l=0.18u w=1.38u
M20 cn CK VSS VSS N l=0.18u w=0.68u
M21 VDD CK cn VDD P l=0.18u w=1.02u
M22 c cn VSS VSS N l=0.18u w=0.42u
M23 VDD cn c VDD P l=0.18u w=0.64u
M24 hnet41 c pm VDD P l=0.18u w=0.66u
M25 VDD D hnet41 VDD P l=0.18u w=0.66u
M26 hnet39 D VSS VSS N l=0.18u w=0.44u
M27 pm cn hnet39 VSS N l=0.18u w=0.44u
M28 hnet47 c net68 VDD P l=0.18u w=0.3u
M29 VDD s hnet47 VDD P l=0.18u w=0.3u
M30 hnet45 s VSS VSS N l=0.18u w=0.3u
M31 net68 cn hnet45 VSS N l=0.18u w=0.3u
M32 hnet53 cn pm VDD P l=0.18u w=0.42u
M33 VDD m hnet53 VDD P l=0.18u w=0.42u
M34 hnet51 m VSS VSS N l=0.18u w=0.3u
M35 pm c hnet51 VSS N l=0.18u w=0.3u
.ends DFFRHQX2
*.SCALE meter
.GLOBAL GND VSS VDD

.subckt DFFRHQX4 Q CK D RN
M0 net68 cn net55 VDD P l=0.18u w=3.84u
M1 net68 c net55 VSS N l=0.18u w=2.56u
M2 VDD net57 hnet17 VDD P l=0.18u w=1.44u
M3 hnet17 net68 Q VDD P l=0.18u w=1.44u
M4 VDD net57 hnet15 VDD P l=0.18u w=1.44u
M5 hnet15 net68 Q VDD P l=0.18u w=1.44u
M6 VDD net57 hnet19 VDD P l=0.18u w=1.44u
M7 hnet19 net68 Q VDD P l=0.18u w=1.44u
M8 Q net57 VSS VSS N l=0.18u w=2.16u
M9 Q net68 VSS VSS N l=0.18u w=2.16u
M10 VDD net57 hnet24 VDD P l=0.18u w=1.56u
M11 hnet24 pm m VDD P l=0.18u w=1.56u
M12 m net57 VSS VSS N l=0.18u w=0.78u
M13 m pm VSS VSS N l=0.18u w=0.78u
M14 VDD net57 hnet28 VDD P l=0.18u w=0.56u
M15 hnet28 net68 s VDD P l=0.18u w=0.56u
M16 s net57 VSS VSS N l=0.18u w=0.3u
M17 s net68 VSS VSS N l=0.18u w=0.3u
M18 net55 m VSS VSS N l=0.18u w=2.56u
M19 VDD m net55 VDD P l=0.18u w=3.84u
M20 net57 RN VSS VSS N l=0.18u w=1.64u
M21 VDD RN net57 VDD P l=0.18u w=2.46u
M22 cn CK VSS VSS N l=0.18u w=1.1u
M23 VDD CK cn VDD P l=0.18u w=1.64u
M24 c cn VSS VSS N l=0.18u w=0.68u
M25 VDD cn c VDD P l=0.18u w=1.02u
M26 hnet42 c pm VDD P l=0.18u w=1.12u
M27 VDD D hnet42 VDD P l=0.18u w=1.12u
M28 hnet40 D VSS VSS N l=0.18u w=0.74u
M29 pm cn hnet40 VSS N l=0.18u w=0.74u
M30 hnet48 c net68 VDD P l=0.18u w=0.3u
M31 VDD s hnet48 VDD P l=0.18u w=0.3u
M32 hnet46 s VSS VSS N l=0.18u w=0.3u
M33 net68 cn hnet46 VSS N l=0.18u w=0.3u
M34 hnet54 cn pm VDD P l=0.18u w=0.42u
M35 VDD m hnet54 VDD P l=0.18u w=0.42u
M36 hnet52 m VSS VSS N l=0.18u w=0.3u
M37 pm c hnet52 VSS N l=0.18u w=0.3u
.ends DFFRHQX4
*.SCALE meter
.GLOBAL GND VSS VDD

.subckt DFFRHQXL Q CK D RN
M0 net68 cn net55 VDD P l=0.18u w=0.84u
M1 net68 c net55 VSS N l=0.18u w=0.56u
M2 VDD net57 hnet16 VDD P l=0.18u w=0.56u
M3 hnet16 pm m VDD P l=0.18u w=0.56u
M4 m net57 VSS VSS N l=0.18u w=0.3u
M5 m pm VSS VSS N l=0.18u w=0.3u
M6 VDD net57 hnet22 VDD P l=0.18u w=0.84u
M7 hnet22 net68 Q VDD P l=0.18u w=0.84u
M8 Q net57 VSS VSS N l=0.18u w=0.42u
M9 Q net68 VSS VSS N l=0.18u w=0.42u
M10 VDD net57 hnet28 VDD P l=0.18u w=0.56u
M11 hnet28 net68 s VDD P l=0.18u w=0.56u
M12 s net57 VSS VSS N l=0.18u w=0.3u
M13 s net68 VSS VSS N l=0.18u w=0.3u
M14 net55 m VSS VSS N l=0.18u w=0.3u
M15 VDD m net55 VDD P l=0.18u w=0.42u
M16 net57 RN VSS VSS N l=0.18u w=0.3u
M17 VDD RN net57 VDD P l=0.18u w=0.42u
M18 cn CK VSS VSS N l=0.18u w=0.3u
M19 VDD CK cn VDD P l=0.18u w=0.42u
M20 c cn VSS VSS N l=0.18u w=0.3u
M21 VDD cn c VDD P l=0.18u w=0.42u
M22 hnet44 c pm VDD P l=0.18u w=0.84u
M23 VDD D hnet44 VDD P l=0.18u w=0.84u
M24 hnet42 D VSS VSS N l=0.18u w=0.56u
M25 pm cn hnet42 VSS N l=0.18u w=0.56u
M26 hnet50 c net68 VDD P l=0.18u w=0.3u
M27 VDD s hnet50 VDD P l=0.18u w=0.3u
M28 hnet48 s VSS VSS N l=0.18u w=0.3u
M29 net68 cn hnet48 VSS N l=0.18u w=0.3u
M30 hnet56 cn pm VDD P l=0.18u w=0.42u
M31 VDD m hnet56 VDD P l=0.18u w=0.42u
M32 hnet54 m VSS VSS N l=0.18u w=0.3u
M33 pm c hnet54 VSS N l=0.18u w=0.3u
.ends DFFRHQXL
*.SCALE meter
.GLOBAL GND VSS VDD

.subckt DFFRX1 Q QN CK D RN
M0 VDD net52 hnet17 VDD P l=0.18u w=0.88u
M1 hnet17 net67 s VDD P l=0.18u w=0.88u
M2 s net52 VSS VSS N l=0.18u w=0.44u
M3 s net67 VSS VSS N l=0.18u w=0.44u
M4 VDD net52 hnet23 VDD P l=0.18u w=0.56u
M5 hnet23 pm m VDD P l=0.18u w=0.56u
M6 m net52 VSS VSS N l=0.18u w=0.3u
M7 m pm VSS VSS N l=0.18u w=0.3u
M8 net46 s VSS VSS N l=0.18u w=0.3u
M9 VDD s net46 VDD P l=0.18u w=0.42u
M10 QN s VSS VSS N l=0.18u w=0.6u
M11 VDD s QN VDD P l=0.18u w=0.9u
M12 Q net46 VSS VSS N l=0.18u w=0.6u
M13 VDD net46 Q VDD P l=0.18u w=0.9u
M14 net52 RN VSS VSS N l=0.18u w=0.34u
M15 VDD RN net52 VDD P l=0.18u w=0.52u
M16 cn CK VSS VSS N l=0.18u w=0.4u
M17 VDD CK cn VDD P l=0.18u w=0.6u
M18 c cn VSS VSS N l=0.18u w=0.3u
M19 VDD cn c VDD P l=0.18u w=0.42u
M20 hnet43 cn net67 VDD P l=0.18u w=0.64u
M21 VDD m hnet43 VDD P l=0.18u w=0.64u
M22 hnet41 m VSS VSS N l=0.18u w=0.42u
M23 net67 c hnet41 VSS N l=0.18u w=0.42u
M24 hnet49 c pm VDD P l=0.18u w=0.42u
M25 VDD D hnet49 VDD P l=0.18u w=0.42u
M26 hnet47 D VSS VSS N l=0.18u w=0.3u
M27 pm cn hnet47 VSS N l=0.18u w=0.3u
M28 hnet55 c net67 VDD P l=0.18u w=0.3u
M29 VDD s hnet55 VDD P l=0.18u w=0.3u
M30 hnet53 s VSS VSS N l=0.18u w=0.3u
M31 net67 cn hnet53 VSS N l=0.18u w=0.3u
M32 hnet61 cn pm VDD P l=0.18u w=0.42u
M33 VDD m hnet61 VDD P l=0.18u w=0.42u
M34 hnet59 m VSS VSS N l=0.18u w=0.3u
M35 pm c hnet59 VSS N l=0.18u w=0.3u
.ends DFFRX1
*.SCALE meter
.GLOBAL GND VSS VDD

.subckt DFFRX2 Q QN CK D RN
M0 hnet25 cn net67 VDD P l=0.18u w=0.54u
M1 hnet22 cn net67 VDD P l=0.18u w=0.54u
M2 VDD m hnet25 VDD P l=0.18u w=0.54u
M3 VDD m hnet22 VDD P l=0.18u w=0.54u
M4 hnet17 m VSS VSS N l=0.18u w=0.36u
M5 hnet18 m VSS VSS N l=0.18u w=0.36u
M6 net67 c hnet17 VSS N l=0.18u w=0.36u
M7 net67 c hnet18 VSS N l=0.18u w=0.36u
M8 QN s VSS VSS N l=0.19u w=1.24u
M9 VDD s QN VDD P l=0.18u w=1.8u
M10 Q net54 VSS VSS N l=0.19u w=1.24u
M11 VDD net54 Q VDD P l=0.18u w=1.8u
M12 VDD net56 hnet31 VDD P l=0.18u w=1.52u
M13 hnet31 net67 s VDD P l=0.18u w=1.52u
M14 s net56 VSS VSS N l=0.18u w=0.76u
M15 s net67 VSS VSS N l=0.18u w=0.76u
M16 VDD net56 hnet35 VDD P l=0.18u w=0.56u
M17 hnet35 pm m VDD P l=0.18u w=0.56u
M18 m net56 VSS VSS N l=0.18u w=0.3u
M19 m pm VSS VSS N l=0.18u w=0.3u
M20 net54 s VSS VSS N l=0.18u w=0.48u
M21 VDD s net54 VDD P l=0.18u w=0.72u
M22 net56 RN VSS VSS N l=0.18u w=0.5u
M23 VDD RN net56 VDD P l=0.18u w=0.76u
M24 cn CK VSS VSS N l=0.18u w=0.42u
M25 VDD CK cn VDD P l=0.18u w=0.64u
M26 c cn VSS VSS N l=0.18u w=0.3u
M27 VDD cn c VDD P l=0.18u w=0.44u
M28 hnet49 c pm VDD P l=0.18u w=0.42u
M29 VDD D hnet49 VDD P l=0.18u w=0.42u
M30 hnet47 D VSS VSS N l=0.18u w=0.3u
M31 pm cn hnet47 VSS N l=0.18u w=0.3u
M32 hnet55 c net67 VDD P l=0.18u w=0.3u
M33 VDD s hnet55 VDD P l=0.18u w=0.3u
M34 hnet53 s VSS VSS N l=0.18u w=0.3u
M35 net67 cn hnet53 VSS N l=0.18u w=0.3u
M36 hnet61 cn pm VDD P l=0.18u w=0.42u
M37 VDD m hnet61 VDD P l=0.18u w=0.42u
M38 hnet59 m VSS VSS N l=0.18u w=0.3u
M39 pm c hnet59 VSS N l=0.18u w=0.3u
.ends DFFRX2
*.SCALE meter
.GLOBAL GND VSS VDD

.subckt DFFRX4 Q QN CK D RN
M0 hnet25 cn net67 VDD P l=0.18u w=1u
M1 hnet22 cn net67 VDD P l=0.18u w=1u
M2 VDD m hnet25 VDD P l=0.18u w=1u
M3 VDD m hnet22 VDD P l=0.18u w=1u
M4 hnet17 m VSS VSS N l=0.18u w=0.7u
M5 hnet18 m VSS VSS N l=0.18u w=0.7u
M6 net67 c hnet17 VSS N l=0.18u w=0.7u
M7 net67 c hnet18 VSS N l=0.18u w=0.7u
M8 net44 s VSS VSS N l=0.19u w=0.96u
M9 VDD s net44 VDD P l=0.18u w=1.44u
M10 VDD net56 hnet30 VDD P l=0.18u w=1.4u
M11 hnet30 net67 s VDD P l=0.18u w=1.4u
M12 VDD net56 hnet28 VDD P l=0.18u w=1.4u
M13 hnet28 net67 s VDD P l=0.18u w=1.4u
M14 s net56 VSS VSS N l=0.18u w=1.4u
M15 s net67 VSS VSS N l=0.18u w=1.4u
M16 VDD net56 hnet34 VDD P l=0.18u w=0.92u
M17 hnet34 pm m VDD P l=0.18u w=0.92u
M18 m net56 VSS VSS N l=0.18u w=0.46u
M19 m pm VSS VSS N l=0.18u w=0.46u
M20 QN s VSS VSS N l=0.18u w=2.38u
M21 VDD s QN VDD P l=0.18u w=3.52u
M22 Q net44 VSS VSS N l=0.18u w=2.38u
M23 VDD net44 Q VDD P l=0.18u w=3.52u
M24 net56 RN VSS VSS N l=0.18u w=0.9u
M25 VDD RN net56 VDD P l=0.18u w=1.36u
M26 cn CK VSS VSS N l=0.18u w=0.62u
M27 VDD CK cn VDD P l=0.18u w=0.96u
M28 c cn VSS VSS N l=0.18u w=0.46u
M29 VDD cn c VDD P l=0.18u w=0.66u
M30 hnet50 c pm VDD P l=0.18u w=0.66u
M31 VDD D hnet50 VDD P l=0.18u w=0.66u
M32 hnet48 D VSS VSS N l=0.18u w=0.44u
M33 pm cn hnet48 VSS N l=0.18u w=0.44u
M34 hnet56 c net67 VDD P l=0.18u w=0.3u
M35 VDD s hnet56 VDD P l=0.18u w=0.3u
M36 hnet54 s VSS VSS N l=0.18u w=0.3u
M37 net67 cn hnet54 VSS N l=0.18u w=0.3u
M38 hnet62 cn pm VDD P l=0.18u w=0.42u
M39 VDD m hnet62 VDD P l=0.18u w=0.42u
M40 hnet60 m VSS VSS N l=0.18u w=0.3u
M41 pm c hnet60 VSS N l=0.18u w=0.3u
.ends DFFRX4
*.SCALE meter
.GLOBAL GND VSS VDD

.subckt DFFRXL Q QN CK D RN
M0 VDD net52 hnet17 VDD P l=0.18u w=0.56u
M1 hnet17 net67 s VDD P l=0.18u w=0.56u
M2 s net52 VSS VSS N l=0.18u w=0.3u
M3 s net67 VSS VSS N l=0.18u w=0.3u
M4 VDD net52 hnet23 VDD P l=0.18u w=0.56u
M5 hnet23 pm m VDD P l=0.18u w=0.56u
M6 m net52 VSS VSS N l=0.18u w=0.3u
M7 m pm VSS VSS N l=0.18u w=0.3u
M8 net46 s VSS VSS N l=0.18u w=0.3u
M9 VDD s net46 VDD P l=0.18u w=0.42u
M10 QN s VSS VSS N l=0.18u w=0.42u
M11 VDD s QN VDD P l=0.18u w=0.64u
M12 Q net46 VSS VSS N l=0.18u w=0.42u
M13 VDD net46 Q VDD P l=0.18u w=0.64u
M14 net52 RN VSS VSS N l=0.18u w=0.3u
M15 VDD RN net52 VDD P l=0.18u w=0.42u
M16 cn CK VSS VSS N l=0.18u w=0.3u
M17 VDD CK cn VDD P l=0.18u w=0.42u
M18 c cn VSS VSS N l=0.18u w=0.3u
M19 VDD cn c VDD P l=0.18u w=0.42u
M20 hnet43 cn net67 VDD P l=0.18u w=0.84u
M21 VDD m hnet43 VDD P l=0.18u w=0.84u
M22 hnet41 m VSS VSS N l=0.18u w=0.56u
M23 net67 c hnet41 VSS N l=0.18u w=0.56u
M24 hnet49 c pm VDD P l=0.18u w=0.84u
M25 VDD D hnet49 VDD P l=0.18u w=0.84u
M26 hnet47 D VSS VSS N l=0.18u w=0.56u
M27 pm cn hnet47 VSS N l=0.18u w=0.56u
M28 hnet55 c net67 VDD P l=0.18u w=0.3u
M29 VDD s hnet55 VDD P l=0.18u w=0.3u
M30 hnet53 s VSS VSS N l=0.18u w=0.3u
M31 net67 cn hnet53 VSS N l=0.18u w=0.3u
M32 hnet61 cn pm VDD P l=0.18u w=0.42u
M33 VDD m hnet61 VDD P l=0.18u w=0.42u
M34 hnet59 m VSS VSS N l=0.18u w=0.3u
M35 pm c hnet59 VSS N l=0.18u w=0.3u
.ends DFFRXL
*.SCALE meter
.GLOBAL GND VSS VDD

.subckt DFFSHQX1 Q CK D SN
M0 net62 c net51 VSS N l=0.18u w=0.74u
M1 net62 cn net51 VDD P l=0.18u w=1.12u
M2 VDD SN Q VDD P l=0.18u w=0.9u
M3 VDD net62 Q VDD P l=0.18u w=0.9u
M4 hnet18 SN VSS VSS N l=0.18u w=0.8u
M5 Q net62 hnet18 VSS N l=0.18u w=0.8u
M6 VDD SN s VDD P l=0.18u w=0.32u
M7 VDD net62 s VDD P l=0.18u w=0.32u
M8 hnet24 SN VSS VSS N l=0.18u w=0.3u
M9 s net62 hnet24 VSS N l=0.18u w=0.3u
M10 VDD SN m VDD P l=0.18u w=0.44u
M11 VDD pm m VDD P l=0.18u w=0.44u
M12 hnet30 SN VSS VSS N l=0.18u w=0.38u
M13 m pm hnet30 VSS N l=0.18u w=0.38u
M14 net51 m VSS VSS N l=0.18u w=0.74u
M15 VDD m net51 VDD P l=0.18u w=1.12u
M16 c cn VSS VSS N l=0.18u w=0.3u
M17 VDD cn c VDD P l=0.18u w=0.42u
M18 cn CK VSS VSS N l=0.18u w=0.44u
M19 VDD CK cn VDD P l=0.18u w=0.66u
M20 hnet41 c pm VDD P l=0.18u w=0.42u
M21 VDD D hnet41 VDD P l=0.18u w=0.42u
M22 hnet39 D VSS VSS N l=0.18u w=0.3u
M23 pm cn hnet39 VSS N l=0.18u w=0.3u
M24 hnet47 c net62 VDD P l=0.18u w=0.3u
M25 VDD s hnet47 VDD P l=0.18u w=0.3u
M26 hnet45 s VSS VSS N l=0.18u w=0.3u
M27 net62 cn hnet45 VSS N l=0.18u w=0.3u
M28 hnet53 cn pm VDD P l=0.18u w=0.42u
M29 VDD m hnet53 VDD P l=0.18u w=0.42u
M30 hnet51 m VSS VSS N l=0.18u w=0.3u
M31 pm c hnet51 VSS N l=0.18u w=0.3u
.ends DFFSHQX1
*.SCALE meter
.GLOBAL GND VSS VDD

.subckt DFFSHQX2 Q CK D SN
M0 VDD SN Q VDD P l=0.18u w=1.76u
M1 VDD net62 Q VDD P l=0.18u w=1.76u
M2 hnet19 SN VSS VSS N l=0.18u w=0.8u
M3 Q net62 hnet19 VSS N l=0.18u w=0.8u
M4 hnet14 SN VSS VSS N l=0.18u w=0.8u
M5 Q net62 hnet14 VSS N l=0.18u w=0.8u
M6 net62 c net51 VSS N l=0.18u w=1.28u
M7 net62 cn net51 VDD P l=0.18u w=1.92u
M8 VDD SN s VDD P l=0.18u w=0.32u
M9 VDD net62 s VDD P l=0.18u w=0.32u
M10 hnet24 SN VSS VSS N l=0.18u w=0.3u
M11 s net62 hnet24 VSS N l=0.18u w=0.3u
M12 VDD SN m VDD P l=0.18u w=0.66u
M13 VDD pm m VDD P l=0.18u w=0.66u
M14 hnet28 SN VSS VSS N l=0.18u w=0.58u
M15 m pm hnet28 VSS N l=0.18u w=0.58u
M16 net51 m VSS VSS N l=0.18u w=1.28u
M17 VDD m net51 VDD P l=0.18u w=1.92u
M18 c cn VSS VSS N l=0.18u w=0.38u
M19 VDD cn c VDD P l=0.18u w=0.54u
M20 cn CK VSS VSS N l=0.18u w=0.62u
M21 VDD CK cn VDD P l=0.18u w=0.9u
M22 hnet38 c pm VDD P l=0.18u w=0.6u
M23 VDD D hnet38 VDD P l=0.18u w=0.6u
M24 hnet36 D VSS VSS N l=0.18u w=0.4u
M25 pm cn hnet36 VSS N l=0.18u w=0.4u
M26 hnet44 c net62 VDD P l=0.18u w=0.3u
M27 VDD s hnet44 VDD P l=0.18u w=0.3u
M28 hnet42 s VSS VSS N l=0.18u w=0.3u
M29 net62 cn hnet42 VSS N l=0.18u w=0.3u
M30 hnet50 cn pm VDD P l=0.18u w=0.42u
M31 VDD m hnet50 VDD P l=0.18u w=0.42u
M32 hnet48 m VSS VSS N l=0.18u w=0.3u
M33 pm c hnet48 VSS N l=0.18u w=0.3u
.ends DFFSHQX2
*.SCALE meter
.GLOBAL GND VSS VDD

.subckt DFFSHQX4 Q CK D SN
M0 VDD SN Q VDD P l=0.18u w=3.52u
M1 VDD net62 Q VDD P l=0.18u w=3.52u
M2 hnet14 SN VSS VSS N l=0.18u w=1.06u
M3 Q net62 hnet14 VSS N l=0.18u w=1.06u
M4 hnet16 SN VSS VSS N l=0.18u w=1.06u
M5 Q net62 hnet16 VSS N l=0.18u w=1.06u
M6 hnet18 SN VSS VSS N l=0.18u w=1.06u
M7 Q net62 hnet18 VSS N l=0.18u w=1.06u
M8 net62 c net51 VSS N l=0.18u w=2.34u
M9 net62 cn net51 VDD P l=0.18u w=3.54u
M10 VDD SN s VDD P l=0.18u w=0.32u
M11 VDD net62 s VDD P l=0.18u w=0.32u
M12 hnet25 SN VSS VSS N l=0.18u w=0.3u
M13 s net62 hnet25 VSS N l=0.18u w=0.3u
M14 VDD SN m VDD P l=0.18u w=1.1u
M15 VDD pm m VDD P l=0.18u w=1.1u
M16 hnet29 SN VSS VSS N l=0.18u w=0.96u
M17 m pm hnet29 VSS N l=0.18u w=0.96u
M18 net51 m VSS VSS N l=0.18u w=2.34u
M19 VDD m net51 VDD P l=0.18u w=3.52u
M20 c cn VSS VSS N l=0.18u w=0.62u
M21 VDD cn c VDD P l=0.18u w=0.92u
M22 cn CK VSS VSS N l=0.18u w=0.98u
M23 VDD CK cn VDD P l=0.18u w=1.48u
M24 hnet39 c pm VDD P l=0.18u w=1u
M25 VDD D hnet39 VDD P l=0.18u w=1u
M26 hnet37 D VSS VSS N l=0.18u w=0.66u
M27 pm cn hnet37 VSS N l=0.18u w=0.66u
M28 hnet45 c net62 VDD P l=0.18u w=0.3u
M29 VDD s hnet45 VDD P l=0.18u w=0.3u
M30 hnet43 s VSS VSS N l=0.18u w=0.3u
M31 net62 cn hnet43 VSS N l=0.18u w=0.3u
M32 hnet51 cn pm VDD P l=0.18u w=0.42u
M33 VDD m hnet51 VDD P l=0.18u w=0.42u
M34 hnet49 m VSS VSS N l=0.18u w=0.3u
M35 pm c hnet49 VSS N l=0.18u w=0.3u
.ends DFFSHQX4
*.SCALE meter
.GLOBAL GND VSS VDD

.subckt DFFSHQXL Q CK D SN
M0 net62 c net51 VSS N l=0.18u w=0.56u
M1 net62 cn net51 VDD P l=0.18u w=0.84u
M2 VDD SN Q VDD P l=0.18u w=0.64u
M3 VDD net62 Q VDD P l=0.18u w=0.64u
M4 hnet18 SN VSS VSS N l=0.18u w=0.56u
M5 Q net62 hnet18 VSS N l=0.18u w=0.56u
M6 VDD SN s VDD P l=0.18u w=0.42u
M7 VDD net62 s VDD P l=0.18u w=0.42u
M8 hnet24 SN VSS VSS N l=0.18u w=0.36u
M9 s net62 hnet24 VSS N l=0.18u w=0.36u
M10 VDD SN m VDD P l=0.18u w=0.42u
M11 VDD pm m VDD P l=0.18u w=0.42u
M12 hnet30 SN VSS VSS N l=0.18u w=0.36u
M13 m pm hnet30 VSS N l=0.18u w=0.36u
M14 net51 m VSS VSS N l=0.18u w=0.3u
M15 VDD m net51 VDD P l=0.18u w=0.42u
M16 c cn VSS VSS N l=0.18u w=0.3u
M17 VDD cn c VDD P l=0.18u w=0.42u
M18 cn CK VSS VSS N l=0.18u w=0.3u
M19 VDD CK cn VDD P l=0.18u w=0.42u
M20 hnet41 c pm VDD P l=0.18u w=0.84u
M21 VDD D hnet41 VDD P l=0.18u w=0.84u
M22 hnet39 D VSS VSS N l=0.18u w=0.56u
M23 pm cn hnet39 VSS N l=0.18u w=0.56u
M24 hnet47 c net62 VDD P l=0.18u w=0.3u
M25 VDD s hnet47 VDD P l=0.18u w=0.3u
M26 hnet45 s VSS VSS N l=0.18u w=0.3u
M27 net62 cn hnet45 VSS N l=0.18u w=0.3u
M28 hnet53 cn pm VDD P l=0.18u w=0.42u
M29 VDD m hnet53 VDD P l=0.18u w=0.42u
M30 hnet51 m VSS VSS N l=0.18u w=0.3u
M31 pm c hnet51 VSS N l=0.18u w=0.3u
.ends DFFSHQXL
*.SCALE meter
.GLOBAL GND VSS VDD

.subckt DFFSRHQX1 Q CK D RN SN
M0 VDD net127 hnet25 VDD P l=0.18u w=0.62u
M1 hnet25 pm m VDD P l=0.18u w=0.62u
M2 VDD net127 hnet29 VDD P l=0.18u w=1.2u
M3 hnet29 net138 Q VDD P l=0.18u w=1.2u
M4 net138 cn net125 VDD P l=0.18u w=1.24u
M5 Q SN VDD VDD P l=0.18u w=0.9u
M6 s SN VDD VDD P l=0.18u w=0.3u
M7 s net138 net87 VDD P l=0.18u w=0.3u
M8 net87 net127 VDD VDD P l=0.18u w=0.3u
M9 m SN VDD VDD P l=0.18u w=0.46u
M10 net138 c net125 VSS N l=0.18u w=0.82u
M11 Q net127 net106 VSS N l=0.18u w=0.8u
M12 Q net138 net106 VSS N l=0.18u w=0.8u
M13 net106 SN VSS VSS N l=0.18u w=0.8u
M14 s net127 net115 VSS N l=0.18u w=0.3u
M15 s net138 net115 VSS N l=0.18u w=0.3u
M16 net115 SN VSS VSS N l=0.18u w=0.3u
M17 m net127 net124 VSS N l=0.18u w=0.4u
M18 m pm net124 VSS N l=0.18u w=0.4u
M19 net124 SN VSS VSS N l=0.18u w=0.4u
M20 net125 m VSS VSS N l=0.18u w=0.82u
M21 VDD m net125 VDD P l=0.18u w=1.24u
M22 net127 RN VSS VSS N l=0.18u w=0.56u
M23 VDD RN net127 VDD P l=0.18u w=0.84u
M24 c cn VSS VSS N l=0.18u w=0.3u
M25 VDD cn c VDD P l=0.18u w=0.44u
M26 cn CK VSS VSS N l=0.18u w=0.48u
M27 VDD CK cn VDD P l=0.18u w=0.72u
M28 hnet41 c pm VDD P l=0.18u w=0.48u
M29 VDD D hnet41 VDD P l=0.18u w=0.48u
M30 hnet39 D VSS VSS N l=0.18u w=0.32u
M31 pm cn hnet39 VSS N l=0.18u w=0.32u
M32 hnet47 c net138 VDD P l=0.18u w=0.3u
M33 VDD s hnet47 VDD P l=0.18u w=0.3u
M34 hnet45 s VSS VSS N l=0.18u w=0.3u
M35 net138 cn hnet45 VSS N l=0.18u w=0.3u
M36 hnet53 cn pm VDD P l=0.18u w=0.42u
M37 VDD m hnet53 VDD P l=0.18u w=0.42u
M38 hnet51 m VSS VSS N l=0.18u w=0.3u
M39 pm c hnet51 VSS N l=0.18u w=0.3u
.ends DFFSRHQX1
*.SCALE meter
.GLOBAL GND VSS VDD

.subckt DFFSRHQX2 Q CK D RN SN
M0 VDD net127 hnet25 VDD P l=0.18u w=0.96u
M1 hnet25 pm m VDD P l=0.18u w=0.96u
M2 VDD net127 hnet30 VDD P l=0.18u w=1.2u
M3 hnet30 net138 Q VDD P l=0.18u w=1.2u
M4 VDD net127 hnet27 VDD P l=0.18u w=1.2u
M5 hnet27 net138 Q VDD P l=0.18u w=1.2u
M6 net138 cn net125 VDD P l=0.18u w=2.16u
M7 Q SN VDD VDD P l=0.18u w=1.8u
M8 s SN VDD VDD P l=0.18u w=0.3u
M9 s net138 net87 VDD P l=0.18u w=0.3u
M10 net87 net127 VDD VDD P l=0.18u w=0.3u
M11 m SN VDD VDD P l=0.18u w=0.72u
M12 net138 c net125 VSS N l=0.18u w=1.44u
M13 Q net127 net106 VSS N l=0.18u w=1.58u
M14 Q net138 net106 VSS N l=0.18u w=1.58u
M15 net106 SN VSS VSS N l=0.18u w=1.58u
M16 s net127 net115 VSS N l=0.18u w=0.3u
M17 s net138 net115 VSS N l=0.18u w=0.3u
M18 net115 SN VSS VSS N l=0.18u w=0.3u
M19 m net127 net124 VSS N l=0.18u w=0.64u
M20 m pm net124 VSS N l=0.18u w=0.64u
M21 net124 SN VSS VSS N l=0.18u w=0.64u
M22 net125 m VSS VSS N l=0.18u w=1.44u
M23 VDD m net125 VDD P l=0.18u w=2.16u
M24 net127 RN VSS VSS N l=0.18u w=0.94u
M25 VDD RN net127 VDD P l=0.18u w=1.48u
M26 c cn VSS VSS N l=0.18u w=0.44u
M27 VDD cn c VDD P l=0.18u w=0.66u
M28 cn CK VSS VSS N l=0.18u w=0.7u
M29 VDD CK cn VDD P l=0.18u w=1.04u
M30 hnet42 c pm VDD P l=0.18u w=0.76u
M31 VDD D hnet42 VDD P l=0.18u w=0.76u
M32 hnet40 D VSS VSS N l=0.18u w=0.5u
M33 pm cn hnet40 VSS N l=0.18u w=0.5u
M34 hnet48 c net138 VDD P l=0.18u w=0.3u
M35 VDD s hnet48 VDD P l=0.18u w=0.3u
M36 hnet46 s VSS VSS N l=0.18u w=0.3u
M37 net138 cn hnet46 VSS N l=0.18u w=0.3u
M38 hnet54 cn pm VDD P l=0.18u w=0.42u
M39 VDD m hnet54 VDD P l=0.18u w=0.42u
M40 hnet52 m VSS VSS N l=0.18u w=0.3u
M41 pm c hnet52 VSS N l=0.18u w=0.3u
.ends DFFSRHQX2
*.SCALE meter
.GLOBAL GND VSS VDD

.subckt DFFSRHQX4 Q CK D RN SN
M0 VDD net127 hnet25 VDD P l=0.18u w=1.66u
M1 hnet25 pm m VDD P l=0.18u w=1.66u
M2 VDD net127 hnet32 VDD P l=0.18u w=1.2u
M3 hnet32 net138 Q VDD P l=0.18u w=1.2u
M4 VDD net127 hnet27 VDD P l=0.18u w=1.2u
M5 hnet27 net138 Q VDD P l=0.18u w=1.2u
M6 VDD net127 hnet29 VDD P l=0.18u w=1.2u
M7 hnet29 net138 Q VDD P l=0.18u w=1.2u
M8 VDD net127 hnet28 VDD P l=0.18u w=1.2u
M9 hnet28 net138 Q VDD P l=0.18u w=1.2u
M10 net138 cn net125 VDD P l=0.18u w=4.04u
M11 Q SN VDD VDD P l=0.18u w=3.6u
M12 s SN VDD VDD P l=0.18u w=0.3u
M13 s net138 net87 VDD P l=0.18u w=0.3u
M14 net87 net127 VDD VDD P l=0.18u w=0.3u
M15 m SN VDD VDD P l=0.18u w=1.24u
M16 net138 c net125 VSS N l=0.18u w=2.7u
M17 Q net127 net106 VSS N l=0.18u w=3.16u
M18 Q net138 net106 VSS N l=0.18u w=3.16u
M19 net106 SN VSS VSS N l=0.18u w=3.16u
M20 s net127 net115 VSS N l=0.18u w=0.3u
M21 s net138 net115 VSS N l=0.18u w=0.3u
M22 net115 SN VSS VSS N l=0.18u w=0.3u
M23 m net127 net124 VSS N l=0.18u w=1.05u
M24 m pm net124 VSS N l=0.18u w=1.05u
M25 net124 SN VSS VSS N l=0.18u w=1.1u
M26 net125 m VSS VSS N l=0.18u w=2.7u
M27 VDD m net125 VDD P l=0.18u w=4.04u
M28 net127 RN VSS VSS N l=0.18u w=1.8u
M29 VDD RN net127 VDD P l=0.18u w=2.7u
M30 c cn VSS VSS N l=0.18u w=0.72u
M31 VDD cn c VDD P l=0.18u w=1.08u
M32 cn CK VSS VSS N l=0.18u w=1.18u
M33 VDD CK cn VDD P l=0.18u w=1.64u
M34 hnet44 c pm VDD P l=0.18u w=1.32u
M35 VDD D hnet44 VDD P l=0.18u w=1.32u
M36 hnet42 D VSS VSS N l=0.18u w=0.88u
M37 pm cn hnet42 VSS N l=0.18u w=0.88u
M38 hnet50 c net138 VDD P l=0.18u w=0.3u
M39 VDD s hnet50 VDD P l=0.18u w=0.3u
M40 hnet48 s VSS VSS N l=0.18u w=0.3u
M41 net138 cn hnet48 VSS N l=0.18u w=0.3u
M42 hnet56 cn pm VDD P l=0.18u w=0.42u
M43 VDD m hnet56 VDD P l=0.18u w=0.42u
M44 hnet54 m VSS VSS N l=0.18u w=0.3u
M45 pm c hnet54 VSS N l=0.18u w=0.3u
.ends DFFSRHQX4
*.SCALE meter
.GLOBAL GND VSS VDD

.subckt DFFSRHQXL Q CK D RN SN
M0 VDD net127 hnet25 VDD P l=0.18u w=0.56u
M1 hnet25 pm m VDD P l=0.18u w=0.56u
M2 VDD net127 hnet29 VDD P l=0.18u w=0.84u
M3 hnet29 net138 Q VDD P l=0.18u w=0.84u
M4 net138 cn net125 VDD P l=0.18u w=0.84u
M5 Q SN VDD VDD P l=0.18u w=0.64u
M6 s SN VDD VDD P l=0.18u w=0.42u
M7 s net138 net87 VDD P l=0.18u w=0.56u
M8 net87 net127 VDD VDD P l=0.18u w=0.56u
M9 m SN VDD VDD P l=0.18u w=0.42u
M10 net138 c net125 VSS N l=0.18u w=0.56u
M11 Q net127 net106 VSS N l=0.18u w=0.56u
M12 Q net138 net106 VSS N l=0.18u w=0.56u
M13 net106 SN VSS VSS N l=0.18u w=0.56u
M14 s net127 net115 VSS N l=0.18u w=0.36u
M15 s net138 net115 VSS N l=0.18u w=0.36u
M16 net115 SN VSS VSS N l=0.18u w=0.36u
M17 m net127 net124 VSS N l=0.18u w=0.36u
M18 m pm net124 VSS N l=0.18u w=0.36u
M19 net124 SN VSS VSS N l=0.18u w=0.36u
M20 net125 m VSS VSS N l=0.18u w=0.3u
M21 VDD m net125 VDD P l=0.18u w=0.42u
M22 net127 RN VSS VSS N l=0.18u w=0.42u
M23 VDD RN net127 VDD P l=0.18u w=0.42u
M24 c cn VSS VSS N l=0.18u w=0.3u
M25 VDD cn c VDD P l=0.18u w=0.42u
M26 cn CK VSS VSS N l=0.18u w=0.3u
M27 VDD CK cn VDD P l=0.18u w=0.42u
M28 hnet41 c pm VDD P l=0.18u w=0.84u
M29 VDD D hnet41 VDD P l=0.18u w=0.84u
M30 hnet39 D VSS VSS N l=0.18u w=0.56u
M31 pm cn hnet39 VSS N l=0.18u w=0.56u
M32 hnet47 c net138 VDD P l=0.18u w=0.3u
M33 VDD s hnet47 VDD P l=0.18u w=0.3u
M34 hnet45 s VSS VSS N l=0.18u w=0.3u
M35 net138 cn hnet45 VSS N l=0.18u w=0.3u
M36 hnet53 cn pm VDD P l=0.18u w=0.42u
M37 VDD m hnet53 VDD P l=0.18u w=0.42u
M38 hnet51 m VSS VSS N l=0.18u w=0.3u
M39 pm c hnet51 VSS N l=0.18u w=0.3u
.ends DFFSRHQXL
*.SCALE meter
.GLOBAL GND VSS VDD

.subckt DFFSRX1 Q QN CK D RN SN
M0 VDD net102 hnet25 VDD P l=0.18u w=0.88u
M1 hnet25 net115 s VDD P l=0.18u w=0.88u
M2 s net102 net72 VSS N l=0.18u w=0.58u
M3 s net115 net72 VSS N l=0.18u w=0.58u
M4 net72 SN VSS VSS N l=0.18u w=0.58u
M5 m net102 net81 VSS N l=0.18u w=0.3u
M6 m pm net81 VSS N l=0.18u w=0.3u
M7 net81 SN VSS VSS N l=0.18u w=0.3u
M8 s SN VDD VDD P l=0.18u w=0.66u
M9 m SN VDD VDD P l=0.18u w=0.3u
M10 m pm net89 VDD P l=0.18u w=0.4u
M11 net89 net102 VDD VDD P l=0.18u w=0.4u
M12 c cn VSS VSS N l=0.18u w=0.3u
M13 VDD cn c VDD P l=0.18u w=0.46u
M14 net96 s VSS VSS N l=0.18u w=0.3u
M15 VDD s net96 VDD P l=0.18u w=0.42u
M16 Q net96 VSS VSS N l=0.18u w=0.6u
M17 VDD net96 Q VDD P l=0.18u w=0.9u
M18 QN s VSS VSS N l=0.18u w=0.6u
M19 VDD s QN VDD P l=0.18u w=0.9u
M20 net102 RN VSS VSS N l=0.18u w=0.34u
M21 VDD RN net102 VDD P l=0.18u w=0.52u
M22 cn CK VSS VSS N l=0.18u w=0.4u
M23 VDD CK cn VDD P l=0.18u w=0.6u
M24 hnet41 cn net115 VDD P l=0.18u w=0.68u
M25 VDD m hnet41 VDD P l=0.18u w=0.68u
M26 hnet39 m VSS VSS N l=0.18u w=0.46u
M27 net115 c hnet39 VSS N l=0.18u w=0.46u
M28 hnet47 c pm VDD P l=0.18u w=0.46u
M29 VDD D hnet47 VDD P l=0.18u w=0.46u
M30 hnet45 D VSS VSS N l=0.18u w=0.3u
M31 pm cn hnet45 VSS N l=0.18u w=0.3u
M32 hnet53 c net115 VDD P l=0.18u w=0.3u
M33 VDD s hnet53 VDD P l=0.18u w=0.3u
M34 hnet51 s VSS VSS N l=0.18u w=0.3u
M35 net115 cn hnet51 VSS N l=0.18u w=0.3u
M36 hnet59 cn pm VDD P l=0.18u w=0.46u
M37 VDD m hnet59 VDD P l=0.18u w=0.46u
M38 hnet57 m VSS VSS N l=0.18u w=0.3u
M39 pm c hnet57 VSS N l=0.18u w=0.3u
.ends DFFSRX1
*.SCALE meter
.GLOBAL GND VSS VDD

.subckt DFFSRX2 Q QN CK D RN SN
M0 VDD net102 hnet25 VDD P l=0.18u w=1.52u
M1 hnet25 net115 s VDD P l=0.18u w=1.52u
M2 s net102 net72 VSS N l=0.18u w=1u
M3 s net115 net72 VSS N l=0.18u w=1u
M4 net72 SN VSS VSS N l=0.18u w=1u
M5 m net102 net81 VSS N l=0.18u w=0.38u
M6 m pm net81 VSS N l=0.18u w=0.38u
M7 net81 SN VSS VSS N l=0.18u w=0.38u
M8 s SN VDD VDD P l=0.18u w=1.14u
M9 m SN VDD VDD P l=0.18u w=0.44u
M10 m pm net89 VDD P l=0.18u w=0.58u
M11 net89 net102 VDD VDD P l=0.18u w=0.58u
M12 c cn VSS VSS N l=0.18u w=0.32u
M13 VDD cn c VDD P l=0.18u w=0.48u
M14 net96 s VSS VSS N l=0.18u w=0.44u
M15 VDD s net96 VDD P l=0.18u w=0.72u
M16 Q net96 VSS VSS N l=0.18u w=1.2u
M17 VDD net96 Q VDD P l=0.18u w=1.74u
M18 QN s VSS VSS N l=0.18u w=1.2u
M19 VDD s QN VDD P l=0.18u w=1.74u
M20 net102 RN VSS VSS N l=0.18u w=0.56u
M21 VDD RN net102 VDD P l=0.18u w=0.84u
M22 cn CK VSS VSS N l=0.18u w=0.44u
M23 VDD CK cn VDD P l=0.18u w=0.64u
M24 hnet41 cn net115 VDD P l=0.18u w=1.18u
M25 VDD m hnet41 VDD P l=0.18u w=1.18u
M26 hnet39 m VSS VSS N l=0.18u w=0.8u
M27 net115 c hnet39 VSS N l=0.18u w=0.8u
M28 hnet47 c pm VDD P l=0.18u w=0.46u
M29 VDD D hnet47 VDD P l=0.18u w=0.46u
M30 hnet45 D VSS VSS N l=0.18u w=0.3u
M31 pm cn hnet45 VSS N l=0.18u w=0.3u
M32 hnet53 c net115 VDD P l=0.18u w=0.3u
M33 VDD s hnet53 VDD P l=0.18u w=0.3u
M34 hnet51 s VSS VSS N l=0.18u w=0.3u
M35 net115 cn hnet51 VSS N l=0.18u w=0.3u
M36 hnet59 cn pm VDD P l=0.18u w=0.46u
M37 VDD m hnet59 VDD P l=0.18u w=0.46u
M38 hnet57 m VSS VSS N l=0.18u w=0.3u
M39 pm c hnet57 VSS N l=0.18u w=0.3u
.ends DFFSRX2
*.SCALE meter
.GLOBAL GND VSS VDD

.subckt DFFSRX4 Q QN CK D RN SN
M0 hnet29 cn net115 VDD P l=0.18u w=1.14u
M1 hnet27 cn net115 VDD P l=0.18u w=1.14u
M2 VDD m hnet29 VDD P l=0.18u w=1.14u
M3 VDD m hnet27 VDD P l=0.18u w=1.14u
M4 hnet23 m VSS VSS N l=0.18u w=0.76u
M5 hnet24 m VSS VSS N l=0.18u w=0.76u
M6 net115 c hnet23 VSS N l=0.18u w=0.76u
M7 net115 c hnet24 VSS N l=0.18u w=0.76u
M8 VDD net106 hnet34 VDD P l=0.18u w=1.42u
M9 hnet34 net115 s VDD P l=0.18u w=1.42u
M10 VDD net106 hnet31 VDD P l=0.18u w=1.42u
M11 hnet31 net115 s VDD P l=0.18u w=1.42u
M12 s net106 net76 VSS N l=0.18u w=1.88u
M13 s net115 net76 VSS N l=0.18u w=1.88u
M14 net76 SN VSS VSS N l=0.18u w=1.88u
M15 m net106 net85 VSS N l=0.18u w=0.64u
M16 m pm net85 VSS N l=0.18u w=0.64u
M17 net85 SN VSS VSS N l=0.18u w=0.66u
M18 s SN VDD VDD P l=0.18u w=2.14u
M19 m SN VDD VDD P l=0.18u w=0.76u
M20 m pm net93 VDD P l=0.18u w=1.02u
M21 net93 net106 VDD VDD P l=0.18u w=1.02u
M22 c cn VSS VSS N l=0.18u w=0.5u
M23 VDD cn c VDD P l=0.18u w=0.76u
M24 net100 s VSS VSS N l=0.18u w=0.96u
M25 VDD s net100 VDD P l=0.18u w=1.44u
M26 Q net100 VSS VSS N l=0.18u w=2.4u
M27 VDD net100 Q VDD P l=0.18u w=3.52u
M28 QN s VSS VSS N l=0.18u w=2.4u
M29 VDD s QN VDD P l=0.18u w=3.52u
M30 net106 RN VSS VSS N l=0.18u w=1.02u
M31 VDD RN net106 VDD P l=0.18u w=1.52u
M32 cn CK VSS VSS N l=0.18u w=0.68u
M33 VDD CK cn VDD P l=0.18u w=1.02u
M34 hnet50 c pm VDD P l=0.18u w=0.8u
M35 VDD D hnet50 VDD P l=0.18u w=0.8u
M36 hnet48 D VSS VSS N l=0.18u w=0.54u
M37 pm cn hnet48 VSS N l=0.18u w=0.54u
M38 hnet56 c net115 VDD P l=0.18u w=0.3u
M39 VDD s hnet56 VDD P l=0.18u w=0.3u
M40 hnet54 s VSS VSS N l=0.18u w=0.3u
M41 net115 cn hnet54 VSS N l=0.18u w=0.3u
M42 hnet62 cn pm VDD P l=0.18u w=0.42u
M43 VDD m hnet62 VDD P l=0.18u w=0.42u
M44 hnet60 m VSS VSS N l=0.18u w=0.3u
M45 pm c hnet60 VSS N l=0.18u w=0.3u
.ends DFFSRX4
*.SCALE meter
.GLOBAL GND VSS VDD

.subckt DFFSRXL Q QN CK D RN SN
M0 VDD net102 hnet25 VDD P l=0.18u w=0.56u
M1 hnet25 net115 s VDD P l=0.18u w=0.56u
M2 s net102 net72 VSS N l=0.18u w=0.36u
M3 s net115 net72 VSS N l=0.18u w=0.36u
M4 net72 SN VSS VSS N l=0.18u w=0.36u
M5 m net102 net81 VSS N l=0.18u w=0.36u
M6 m pm net81 VSS N l=0.18u w=0.36u
M7 net81 SN VSS VSS N l=0.18u w=0.36u
M8 s SN VDD VDD P l=0.18u w=0.46u
M9 m SN VDD VDD P l=0.18u w=0.42u
M10 m pm net89 VDD P l=0.18u w=0.56u
M11 net89 net102 VDD VDD P l=0.18u w=0.56u
M12 c cn VSS VSS N l=0.18u w=0.3u
M13 VDD cn c VDD P l=0.18u w=0.46u
M14 net96 s VSS VSS N l=0.18u w=0.3u
M15 VDD s net96 VDD P l=0.18u w=0.42u
M16 Q net96 VSS VSS N l=0.18u w=0.42u
M17 VDD net96 Q VDD P l=0.18u w=0.64u
M18 QN s VSS VSS N l=0.18u w=0.42u
M19 VDD s QN VDD P l=0.18u w=0.64u
M20 net102 RN VSS VSS N l=0.18u w=0.3u
M21 VDD RN net102 VDD P l=0.18u w=0.42u
M22 cn CK VSS VSS N l=0.18u w=0.3u
M23 VDD CK cn VDD P l=0.18u w=0.46u
M24 hnet41 cn net115 VDD P l=0.18u w=0.84u
M25 VDD m hnet41 VDD P l=0.18u w=0.84u
M26 hnet39 m VSS VSS N l=0.18u w=0.56u
M27 net115 c hnet39 VSS N l=0.18u w=0.56u
M28 hnet47 c pm VDD P l=0.18u w=0.84u
M29 VDD D hnet47 VDD P l=0.18u w=0.84u
M30 hnet45 D VSS VSS N l=0.18u w=0.52u
M31 pm cn hnet45 VSS N l=0.18u w=0.52u
M32 hnet53 c net115 VDD P l=0.18u w=0.3u
M33 VDD s hnet53 VDD P l=0.18u w=0.3u
M34 hnet51 s VSS VSS N l=0.18u w=0.3u
M35 net115 cn hnet51 VSS N l=0.18u w=0.3u
M36 hnet59 cn pm VDD P l=0.18u w=0.46u
M37 VDD m hnet59 VDD P l=0.18u w=0.46u
M38 hnet57 m VSS VSS N l=0.18u w=0.3u
M39 pm c hnet57 VSS N l=0.18u w=0.3u
.ends DFFSRXL
*.SCALE meter
.GLOBAL GND VSS VDD

.subckt DFFSX1 Q QN CK D SN
M0 VDD SN s VDD P l=0.18u w=0.66u
M1 VDD net55 s VDD P l=0.18u w=0.66u
M2 hnet19 SN VSS VSS N l=0.18u w=0.58u
M3 s net55 hnet19 VSS N l=0.18u w=0.58u
M4 VDD SN m VDD P l=0.18u w=0.32u
M5 VDD pm m VDD P l=0.18u w=0.32u
M6 hnet25 SN VSS VSS N l=0.18u w=0.3u
M7 m pm hnet25 VSS N l=0.18u w=0.3u
M8 Q net48 VSS VSS N l=0.18u w=0.6u
M9 VDD net48 Q VDD P l=0.18u w=0.9u
M10 QN s VSS VSS N l=0.18u w=0.56u
M11 VDD s QN VDD P l=0.18u w=0.86u
M12 net48 s VSS VSS N l=0.18u w=0.3u
M13 VDD s net48 VDD P l=0.18u w=0.42u
M14 c cn VSS VSS N l=0.18u w=0.3u
M15 VDD cn c VDD P l=0.18u w=0.42u
M16 cn CK VSS VSS N l=0.18u w=0.4u
M17 VDD CK cn VDD P l=0.18u w=0.6u
M18 hnet40 cn net55 VDD P l=0.18u w=0.6u
M19 VDD m hnet40 VDD P l=0.18u w=0.6u
M20 hnet38 m VSS VSS N l=0.18u w=0.4u
M21 net55 c hnet38 VSS N l=0.18u w=0.4u
M22 hnet46 c pm VDD P l=0.18u w=0.42u
M23 VDD D hnet46 VDD P l=0.18u w=0.42u
M24 hnet44 D VSS VSS N l=0.18u w=0.3u
M25 pm cn hnet44 VSS N l=0.18u w=0.3u
M26 hnet52 c net55 VDD P l=0.18u w=0.3u
M27 VDD s hnet52 VDD P l=0.18u w=0.3u
M28 hnet50 s VSS VSS N l=0.18u w=0.3u
M29 net55 cn hnet50 VSS N l=0.18u w=0.3u
M30 hnet58 cn pm VDD P l=0.18u w=0.42u
M31 VDD m hnet58 VDD P l=0.18u w=0.42u
M32 hnet56 m VSS VSS N l=0.18u w=0.3u
M33 pm c hnet56 VSS N l=0.18u w=0.3u
.ends DFFSX1
*.SCALE meter
.GLOBAL GND VSS VDD

.subckt DFFSX2 Q QN CK D SN
M0 VDD SN s VDD P l=0.18u w=1.14u
M1 VDD net55 s VDD P l=0.18u w=1.14u
M2 hnet19 SN VSS VSS N l=0.18u w=1u
M3 s net55 hnet19 VSS N l=0.18u w=1u
M4 VDD SN m VDD P l=0.18u w=0.4u
M5 VDD pm m VDD P l=0.18u w=0.4u
M6 hnet25 SN VSS VSS N l=0.18u w=0.36u
M7 m pm hnet25 VSS N l=0.18u w=0.36u
M8 Q net48 VSS VSS N l=0.18u w=1.2u
M9 VDD net48 Q VDD P l=0.18u w=1.8u
M10 QN s VSS VSS N l=0.18u w=1.2u
M11 VDD s QN VDD P l=0.18u w=1.8u
M12 net48 s VSS VSS N l=0.18u w=0.48u
M13 VDD s net48 VDD P l=0.18u w=0.72u
M14 c cn VSS VSS N l=0.18u w=0.3u
M15 VDD cn c VDD P l=0.18u w=0.44u
M16 cn CK VSS VSS N l=0.18u w=0.42u
M17 VDD CK cn VDD P l=0.18u w=0.64u
M18 hnet40 cn net55 VDD P l=0.18u w=1.02u
M19 VDD m hnet40 VDD P l=0.18u w=1.02u
M20 hnet38 m VSS VSS N l=0.18u w=0.68u
M21 net55 c hnet38 VSS N l=0.18u w=0.68u
M22 hnet46 c pm VDD P l=0.18u w=0.42u
M23 VDD D hnet46 VDD P l=0.18u w=0.42u
M24 hnet44 D VSS VSS N l=0.18u w=0.3u
M25 pm cn hnet44 VSS N l=0.18u w=0.3u
M26 hnet52 c net55 VDD P l=0.18u w=0.3u
M27 VDD s hnet52 VDD P l=0.18u w=0.3u
M28 hnet50 s VSS VSS N l=0.18u w=0.3u
M29 net55 cn hnet50 VSS N l=0.18u w=0.3u
M30 hnet58 cn pm VDD P l=0.18u w=0.42u
M31 VDD m hnet58 VDD P l=0.18u w=0.42u
M32 hnet56 m VSS VSS N l=0.18u w=0.3u
M33 pm c hnet56 VSS N l=0.18u w=0.3u
.ends DFFSX2
*.SCALE meter
.GLOBAL GND VSS VDD

.subckt DFFSX4 Q QN CK D SN
M0 hnet24 cn net39 VDD P l=0.18u w=0.9u
M1 hnet21 cn net39 VDD P l=0.18u w=0.9u
M2 VDD m hnet24 VDD P l=0.18u w=0.9u
M3 VDD m hnet21 VDD P l=0.18u w=0.9u
M4 hnet16 m VSS VSS N l=0.18u w=0.6u
M5 hnet17 m VSS VSS N l=0.18u w=0.6u
M6 net39 c hnet16 VSS N l=0.18u w=0.6u
M7 net39 c hnet17 VSS N l=0.18u w=0.6u
M8 VDD SN s VDD P l=0.18u w=2.12u
M9 VDD net39 s VDD P l=0.18u w=2.12u
M10 hnet29 SN VSS VSS N l=0.18u w=0.94u
M11 s net39 hnet29 VSS N l=0.18u w=0.94u
M12 hnet25 SN VSS VSS N l=0.18u w=0.94u
M13 s net39 hnet25 VSS N l=0.18u w=0.94u
M14 VDD SN m VDD P l=0.18u w=0.62u
M15 VDD pm m VDD P l=0.18u w=0.62u
M16 hnet33 SN VSS VSS N l=0.18u w=0.54u
M17 m pm hnet33 VSS N l=0.18u w=0.54u
M18 Q net52 VSS VSS N l=0.18u w=2.4u
M19 VDD net52 Q VDD P l=0.18u w=3.52u
M20 QN s VSS VSS N l=0.18u w=2.4u
M21 VDD s QN VDD P l=0.18u w=3.6u
M22 net52 s VSS VSS N l=0.18u w=0.96u
M23 VDD s net52 VDD P l=0.18u w=1.44u
M24 c cn VSS VSS N l=0.18u w=0.4u
M25 VDD cn c VDD P l=0.18u w=0.6u
M26 cn CK VSS VSS N l=0.18u w=0.56u
M27 VDD CK cn VDD P l=0.18u w=0.84u
M28 hnet47 c pm VDD P l=0.18u w=0.54u
M29 VDD D hnet47 VDD P l=0.18u w=0.54u
M30 hnet45 D VSS VSS N l=0.18u w=0.36u
M31 pm cn hnet45 VSS N l=0.18u w=0.36u
M32 hnet53 c net39 VDD P l=0.18u w=0.3u
M33 VDD s hnet53 VDD P l=0.18u w=0.3u
M34 hnet51 s VSS VSS N l=0.18u w=0.3u
M35 net39 cn hnet51 VSS N l=0.18u w=0.3u
M36 hnet59 cn pm VDD P l=0.18u w=0.42u
M37 VDD m hnet59 VDD P l=0.18u w=0.42u
M38 hnet57 m VSS VSS N l=0.18u w=0.3u
M39 pm c hnet57 VSS N l=0.18u w=0.3u
.ends DFFSX4
*.SCALE meter
.GLOBAL GND VSS VDD

.subckt DFFSXL Q QN CK D SN
M0 VDD SN s VDD P l=0.18u w=0.42u
M1 VDD net55 s VDD P l=0.18u w=0.42u
M2 hnet19 SN VSS VSS N l=0.18u w=0.36u
M3 s net55 hnet19 VSS N l=0.18u w=0.36u
M4 VDD SN m VDD P l=0.18u w=0.42u
M5 VDD pm m VDD P l=0.18u w=0.42u
M6 hnet25 SN VSS VSS N l=0.18u w=0.36u
M7 m pm hnet25 VSS N l=0.18u w=0.36u
M8 Q net48 VSS VSS N l=0.18u w=0.42u
M9 VDD net48 Q VDD P l=0.18u w=0.64u
M10 QN s VSS VSS N l=0.18u w=0.42u
M11 VDD s QN VDD P l=0.18u w=0.64u
M12 net48 s VSS VSS N l=0.18u w=0.3u
M13 VDD s net48 VDD P l=0.18u w=0.42u
M14 c cn VSS VSS N l=0.18u w=0.3u
M15 VDD cn c VDD P l=0.18u w=0.42u
M16 cn CK VSS VSS N l=0.18u w=0.3u
M17 VDD CK cn VDD P l=0.18u w=0.42u
M18 hnet40 cn net55 VDD P l=0.18u w=0.84u
M19 VDD m hnet40 VDD P l=0.18u w=0.84u
M20 hnet38 m VSS VSS N l=0.18u w=0.56u
M21 net55 c hnet38 VSS N l=0.18u w=0.56u
M22 hnet46 c pm VDD P l=0.18u w=0.84u
M23 VDD D hnet46 VDD P l=0.18u w=0.84u
M24 hnet44 D VSS VSS N l=0.18u w=0.56u
M25 pm cn hnet44 VSS N l=0.18u w=0.56u
M26 hnet52 c net55 VDD P l=0.18u w=0.3u
M27 VDD s hnet52 VDD P l=0.18u w=0.3u
M28 hnet50 s VSS VSS N l=0.18u w=0.3u
M29 net55 cn hnet50 VSS N l=0.18u w=0.3u
M30 hnet58 cn pm VDD P l=0.18u w=0.42u
M31 VDD m hnet58 VDD P l=0.18u w=0.42u
M32 hnet56 m VSS VSS N l=0.18u w=0.3u
M33 pm c hnet56 VSS N l=0.18u w=0.3u
.ends DFFSXL
*.SCALE meter
.GLOBAL GND VSS VDD

.subckt DFFTRX1 Q QN CK D RN
M0 net45 D net48 VSS N l=0.18u w=0.3u
M1 net48 RN VSS VSS N l=0.18u w=0.3u
M2 net82 cn net45 VSS N l=0.18u w=0.3u
M3 net60 D VDD VDD P l=0.18u w=0.3u
M4 net82 c net60 VDD P l=0.18u w=0.3u
M5 net60 RN VDD VDD P l=0.18u w=0.3u
M6 Q net74 VSS VSS N l=0.18u w=0.6u
M7 VDD net74 Q VDD P l=0.18u w=0.9u
M8 QN s VSS VSS N l=0.18u w=0.6u
M9 VDD s QN VDD P l=0.18u w=0.9u
M10 s net74 VSS VSS N l=0.18u w=0.32u
M11 VDD net74 s VDD P l=0.18u w=0.48u
M12 m net82 VSS VSS N l=0.18u w=0.3u
M13 VDD net82 m VDD P l=0.18u w=0.42u
M14 c cn VSS VSS N l=0.18u w=0.3u
M15 VDD cn c VDD P l=0.18u w=0.42u
M16 cn CK VSS VSS N l=0.18u w=0.44u
M17 VDD CK cn VDD P l=0.18u w=0.66u
M18 hnet34 cn net74 VDD P l=0.18u w=1.12u
M19 VDD m hnet34 VDD P l=0.18u w=1.12u
M20 hnet32 m VSS VSS N l=0.18u w=0.74u
M21 net74 c hnet32 VSS N l=0.18u w=0.74u
M22 hnet40 c net74 VDD P l=0.18u w=0.3u
M23 VDD s hnet40 VDD P l=0.18u w=0.3u
M24 hnet38 s VSS VSS N l=0.18u w=0.3u
M25 net74 cn hnet38 VSS N l=0.18u w=0.3u
M26 hnet46 cn net82 VDD P l=0.18u w=0.42u
M27 VDD m hnet46 VDD P l=0.18u w=0.42u
M28 hnet44 m VSS VSS N l=0.18u w=0.3u
M29 net82 c hnet44 VSS N l=0.18u w=0.3u
.ends DFFTRX1
*.SCALE meter
.GLOBAL GND VSS VDD

.subckt DFFTRX2 Q QN CK D RN
M0 hnet26 cn net44 VDD P l=0.18u w=1.04u
M1 hnet24 cn net44 VDD P l=0.18u w=1.04u
M2 VDD m hnet26 VDD P l=0.18u w=1.04u
M3 VDD m hnet24 VDD P l=0.18u w=1.04u
M4 hnet20 m VSS VSS N l=0.18u w=0.7u
M5 hnet21 m VSS VSS N l=0.18u w=0.7u
M6 net44 c hnet20 VSS N l=0.18u w=0.7u
M7 net44 c hnet21 VSS N l=0.18u w=0.7u
M8 net49 D net52 VSS N l=0.18u w=0.3u
M9 net52 RN VSS VSS N l=0.18u w=0.3u
M10 net82 cn net49 VSS N l=0.18u w=0.3u
M11 net64 D VDD VDD P l=0.18u w=0.36u
M12 net82 c net64 VDD P l=0.18u w=0.36u
M13 net64 RN VDD VDD P l=0.18u w=0.36u
M14 Q net44 VSS VSS N l=0.18u w=1.2u
M15 VDD net44 Q VDD P l=0.18u w=1.76u
M16 QN s VSS VSS N l=0.18u w=1.2u
M17 VDD s QN VDD P l=0.18u w=1.76u
M18 s net44 VSS VSS N l=0.18u w=0.56u
M19 VDD net44 s VDD P l=0.18u w=0.84u
M20 m net82 VSS VSS N l=0.18u w=0.46u
M21 VDD net82 m VDD P l=0.18u w=0.68u
M22 c cn VSS VSS N l=0.18u w=0.36u
M23 VDD cn c VDD P l=0.18u w=0.54u
M24 cn CK VSS VSS N l=0.18u w=0.64u
M25 VDD CK cn VDD P l=0.18u w=0.96u
M26 hnet42 c net44 VDD P l=0.18u w=0.3u
M27 VDD s hnet42 VDD P l=0.18u w=0.3u
M28 hnet40 s VSS VSS N l=0.18u w=0.3u
M29 net44 cn hnet40 VSS N l=0.18u w=0.3u
M30 hnet48 cn net82 VDD P l=0.18u w=0.42u
M31 VDD m hnet48 VDD P l=0.18u w=0.42u
M32 hnet46 m VSS VSS N l=0.18u w=0.3u
M33 net82 c hnet46 VSS N l=0.18u w=0.3u
.ends DFFTRX2
*.SCALE meter
.GLOBAL GND VSS VDD

.subckt DFFTRX4 Q QN CK D RN
M0 hnet22 cn net44 VDD P l=0.18u w=1.32u
M1 hnet24 cn net44 VDD P l=0.18u w=1.32u
M2 hnet21 cn net44 VDD P l=0.18u w=1.32u
M3 VDD m hnet22 VDD P l=0.18u w=1.32u
M4 VDD m hnet24 VDD P l=0.18u w=1.32u
M5 VDD m hnet21 VDD P l=0.18u w=1.32u
M6 hnet20 m VSS VSS N l=0.18u w=0.88u
M7 hnet23 m VSS VSS N l=0.18u w=0.88u
M8 hnet27 m VSS VSS N l=0.18u w=0.88u
M9 net44 c hnet20 VSS N l=0.18u w=0.88u
M10 net44 c hnet23 VSS N l=0.18u w=0.88u
M11 net44 c hnet27 VSS N l=0.18u w=0.88u
M12 net49 D net52 VSS N l=0.18u w=0.52u
M13 net52 RN VSS VSS N l=0.18u w=0.52u
M14 net82 cn net49 VSS N l=0.18u w=0.52u
M15 net64 D VDD VDD P l=0.18u w=0.66u
M16 net82 c net64 VDD P l=0.18u w=0.66u
M17 net64 RN VDD VDD P l=0.18u w=0.66u
M18 Q net44 VSS VSS N l=0.18u w=2.4u
M19 VDD net44 Q VDD P l=0.18u w=3.52u
M20 QN s VSS VSS N l=0.18u w=2.4u
M21 VDD s QN VDD P l=0.18u w=3.52u
M22 s net44 VSS VSS N l=0.18u w=1.04u
M23 VDD net44 s VDD P l=0.18u w=1.56u
M24 m net82 VSS VSS N l=0.18u w=0.84u
M25 VDD net82 m VDD P l=0.18u w=1.26u
M26 c cn VSS VSS N l=0.18u w=0.64u
M27 VDD cn c VDD P l=0.18u w=0.96u
M28 cn CK VSS VSS N l=0.18u w=1.1u
M29 VDD CK cn VDD P l=0.18u w=1.64u
M30 hnet44 c net44 VDD P l=0.18u w=0.3u
M31 VDD s hnet44 VDD P l=0.18u w=0.3u
M32 hnet42 s VSS VSS N l=0.18u w=0.3u
M33 net44 cn hnet42 VSS N l=0.18u w=0.3u
M34 hnet50 cn net82 VDD P l=0.18u w=0.42u
M35 VDD m hnet50 VDD P l=0.18u w=0.42u
M36 hnet48 m VSS VSS N l=0.18u w=0.3u
M37 net82 c hnet48 VSS N l=0.18u w=0.3u
.ends DFFTRX4
*.SCALE meter
.GLOBAL GND VSS VDD

.subckt DFFTRXL Q QN CK D RN
M0 net45 D net48 VSS N l=0.18u w=0.44u
M1 net48 RN VSS VSS N l=0.18u w=0.44u
M2 net82 cn net45 VSS N l=0.18u w=0.44u
M3 net60 D VDD VDD P l=0.18u w=0.56u
M4 net82 c net60 VDD P l=0.18u w=0.56u
M5 net60 RN VDD VDD P l=0.18u w=0.56u
M6 Q net74 VSS VSS N l=0.18u w=0.42u
M7 VDD net74 Q VDD P l=0.18u w=0.64u
M8 QN s VSS VSS N l=0.18u w=0.42u
M9 VDD s QN VDD P l=0.18u w=0.64u
M10 s net74 VSS VSS N l=0.18u w=0.3u
M11 VDD net74 s VDD P l=0.18u w=0.42u
M12 m net82 VSS VSS N l=0.18u w=0.3u
M13 VDD net82 m VDD P l=0.18u w=0.42u
M14 c cn VSS VSS N l=0.18u w=0.3u
M15 VDD cn c VDD P l=0.18u w=0.42u
M16 cn CK VSS VSS N l=0.18u w=0.3u
M17 VDD CK cn VDD P l=0.18u w=0.42u
M18 hnet34 cn net74 VDD P l=0.18u w=0.84u
M19 VDD m hnet34 VDD P l=0.18u w=0.84u
M20 hnet32 m VSS VSS N l=0.18u w=0.56u
M21 net74 c hnet32 VSS N l=0.18u w=0.56u
M22 hnet40 c net74 VDD P l=0.18u w=0.3u
M23 VDD s hnet40 VDD P l=0.18u w=0.3u
M24 hnet38 s VSS VSS N l=0.18u w=0.3u
M25 net74 cn hnet38 VSS N l=0.18u w=0.3u
M26 hnet46 cn net82 VDD P l=0.18u w=0.42u
M27 VDD m hnet46 VDD P l=0.18u w=0.42u
M28 hnet44 m VSS VSS N l=0.18u w=0.3u
M29 net82 c hnet44 VSS N l=0.18u w=0.3u
.ends DFFTRXL
*.SCALE meter
.GLOBAL GND VSS VDD

.subckt DFFX1 Q QN CK D
M0 hnet16 cn net43 VDD P l=0.18u w=1.12u
M1 VDD m hnet16 VDD P l=0.18u w=1.12u
M2 hnet14 m VSS VSS N l=0.18u w=0.74u
M3 net43 c hnet14 VSS N l=0.18u w=0.74u
M4 hnet24 c pm VDD P l=0.18u w=0.42u
M5 VDD D hnet24 VDD P l=0.18u w=0.42u
M6 hnet22 D VSS VSS N l=0.18u w=0.3u
M7 pm cn hnet22 VSS N l=0.18u w=0.3u
M8 hnet32 c net43 VDD P l=0.18u w=0.3u
M9 VDD s hnet32 VDD P l=0.18u w=0.3u
M10 hnet30 s VSS VSS N l=0.18u w=0.3u
M11 net43 cn hnet30 VSS N l=0.18u w=0.3u
M12 hnet40 cn pm VDD P l=0.18u w=0.42u
M13 VDD m hnet40 VDD P l=0.18u w=0.42u
M14 hnet38 m VSS VSS N l=0.18u w=0.3u
M15 pm c hnet38 VSS N l=0.18u w=0.3u
M16 s net43 VSS VSS N l=0.18u w=0.32u
M17 VDD net43 s VDD P l=0.18u w=0.48u
M18 m pm VSS VSS N l=0.18u w=0.3u
M19 VDD pm m VDD P l=0.18u w=0.42u
M20 QN s VSS VSS N l=0.18u w=0.6u
M21 VDD s QN VDD P l=0.18u w=0.9u
M22 c cn VSS VSS N l=0.18u w=0.3u
M23 VDD cn c VDD P l=0.18u w=0.44u
M24 cn CK VSS VSS N l=0.18u w=0.42u
M25 VDD CK cn VDD P l=0.18u w=0.64u
M26 Q net43 VSS VSS N l=0.18u w=0.6u
M27 VDD net43 Q VDD P l=0.18u w=0.9u
.ends DFFX1
*.SCALE meter
.GLOBAL GND VSS VDD

.subckt DFFX2 Q QN CK D
M0 hnet22 cn net43 VDD P l=0.18u w=1.05u
M1 hnet19 cn net43 VDD P l=0.18u w=1.05u
M2 VDD m hnet22 VDD P l=0.18u w=1.05u
M3 VDD m hnet19 VDD P l=0.18u w=1.05u
M4 hnet14 m VSS VSS N l=0.18u w=0.7u
M5 hnet15 m VSS VSS N l=0.18u w=0.7u
M6 net43 c hnet14 VSS N l=0.18u w=0.7u
M7 net43 c hnet15 VSS N l=0.18u w=0.7u
M8 hnet26 c pm VDD P l=0.18u w=0.54u
M9 VDD D hnet26 VDD P l=0.18u w=0.54u
M10 hnet24 D VSS VSS N l=0.18u w=0.36u
M11 pm cn hnet24 VSS N l=0.18u w=0.36u
M12 hnet32 c net43 VDD P l=0.18u w=0.3u
M13 VDD s hnet32 VDD P l=0.18u w=0.3u
M14 hnet30 s VSS VSS N l=0.18u w=0.3u
M15 net43 cn hnet30 VSS N l=0.18u w=0.3u
M16 hnet38 cn pm VDD P l=0.18u w=0.42u
M17 VDD m hnet38 VDD P l=0.18u w=0.42u
M18 hnet36 m VSS VSS N l=0.18u w=0.3u
M19 pm c hnet36 VSS N l=0.18u w=0.3u
M20 s net43 VSS VSS N l=0.18u w=0.56u
M21 VDD net43 s VDD P l=0.18u w=0.84u
M22 m pm VSS VSS N l=0.18u w=0.46u
M23 VDD pm m VDD P l=0.18u w=0.68u
M24 QN s VSS VSS N l=0.18u w=1.2u
M25 VDD s QN VDD P l=0.18u w=1.8u
M26 c cn VSS VSS N l=0.18u w=0.44u
M27 VDD cn c VDD P l=0.18u w=0.64u
M28 cn CK VSS VSS N l=0.18u w=0.62u
M29 VDD CK cn VDD P l=0.18u w=0.92u
M30 Q net43 VSS VSS N l=0.18u w=1.2u
M31 VDD net43 Q VDD P l=0.18u w=1.8u
.ends DFFX2
*.SCALE meter
.GLOBAL GND VSS VDD

.subckt DFFX4 Q QN CK D
M0 hnet16 cn net43 VDD P l=0.18u w=1.38u
M1 hnet18 cn net43 VDD P l=0.18u w=1.38u
M2 hnet15 cn net43 VDD P l=0.18u w=1.38u
M3 VDD m hnet16 VDD P l=0.18u w=1.38u
M4 VDD m hnet18 VDD P l=0.18u w=1.38u
M5 VDD m hnet15 VDD P l=0.18u w=1.38u
M6 hnet14 m VSS VSS N l=0.18u w=0.92u
M7 hnet17 m VSS VSS N l=0.18u w=0.92u
M8 hnet22 m VSS VSS N l=0.18u w=0.92u
M9 net43 c hnet14 VSS N l=0.18u w=0.92u
M10 net43 c hnet17 VSS N l=0.18u w=0.92u
M11 net43 c hnet22 VSS N l=0.18u w=0.92u
M12 hnet28 c pm VDD P l=0.18u w=1u
M13 VDD D hnet28 VDD P l=0.18u w=1u
M14 hnet26 D VSS VSS N l=0.18u w=0.66u
M15 pm cn hnet26 VSS N l=0.18u w=0.66u
M16 hnet34 c net43 VDD P l=0.18u w=0.3u
M17 VDD s hnet34 VDD P l=0.18u w=0.3u
M18 hnet32 s VSS VSS N l=0.18u w=0.3u
M19 net43 cn hnet32 VSS N l=0.18u w=0.3u
M20 hnet40 cn pm VDD P l=0.18u w=0.42u
M21 VDD m hnet40 VDD P l=0.18u w=0.42u
M22 hnet38 m VSS VSS N l=0.18u w=0.3u
M23 pm c hnet38 VSS N l=0.18u w=0.3u
M24 s net43 VSS VSS N l=0.18u w=1.04u
M25 VDD net43 s VDD P l=0.18u w=1.56u
M26 m pm VSS VSS N l=0.18u w=0.84u
M27 VDD pm m VDD P l=0.18u w=1.26u
M28 QN s VSS VSS N l=0.18u w=2.4u
M29 VDD s QN VDD P l=0.18u w=3.48u
M30 c cn VSS VSS N l=0.18u w=0.76u
M31 VDD cn c VDD P l=0.18u w=1.14u
M32 cn CK VSS VSS N l=0.18u w=1.06u
M33 VDD CK cn VDD P l=0.18u w=1.6u
M34 Q net43 VSS VSS N l=0.18u w=2.4u
M35 VDD net43 Q VDD P l=0.18u w=3.48u
.ends DFFX4
*.SCALE meter
.GLOBAL GND VSS VDD

.subckt DFFXL Q QN CK D
M0 hnet16 cn net43 VDD P l=0.18u w=0.84u
M1 VDD m hnet16 VDD P l=0.18u w=0.84u
M2 hnet14 m VSS VSS N l=0.18u w=0.56u
M3 net43 c hnet14 VSS N l=0.18u w=0.56u
M4 hnet24 c pm VDD P l=0.18u w=0.84u
M5 VDD D hnet24 VDD P l=0.18u w=0.84u
M6 hnet22 D VSS VSS N l=0.18u w=0.56u
M7 pm cn hnet22 VSS N l=0.18u w=0.56u
M8 hnet32 c net43 VDD P l=0.18u w=0.3u
M9 VDD s hnet32 VDD P l=0.18u w=0.3u
M10 hnet30 s VSS VSS N l=0.18u w=0.3u
M11 net43 cn hnet30 VSS N l=0.18u w=0.3u
M12 hnet40 cn pm VDD P l=0.18u w=0.42u
M13 VDD m hnet40 VDD P l=0.18u w=0.42u
M14 hnet38 m VSS VSS N l=0.18u w=0.3u
M15 pm c hnet38 VSS N l=0.18u w=0.3u
M16 s net43 VSS VSS N l=0.18u w=0.3u
M17 VDD net43 s VDD P l=0.18u w=0.42u
M18 m pm VSS VSS N l=0.18u w=0.3u
M19 VDD pm m VDD P l=0.18u w=0.42u
M20 QN s VSS VSS N l=0.18u w=0.42u
M21 VDD s QN VDD P l=0.18u w=0.64u
M22 c cn VSS VSS N l=0.18u w=0.3u
M23 VDD cn c VDD P l=0.18u w=0.42u
M24 cn CK VSS VSS N l=0.18u w=0.3u
M25 VDD CK cn VDD P l=0.18u w=0.42u
M26 Q net43 VSS VSS N l=0.18u w=0.42u
M27 VDD net43 Q VDD P l=0.18u w=0.64u
.ends DFFXL
*.SCALE meter
.GLOBAL GND VSS VDD

.subckt DLY1X1 Y A
M0 net18 net28 VSS VSS N l=0.18u w=0.28u
M1 net21 net18 VSS VSS N l=0.18u w=0.28u
M2 net18 net28 VDD VDD P l=0.18u w=0.42u
M3 net21 net18 VDD VDD P l=0.18u w=0.42u
M4 net28 A VSS VSS N l=0.18u w=0.28u
M5 VDD A net28 VDD P l=0.18u w=0.42u
M6 Y net21 VSS VSS N l=0.18u w=0.6u
M7 VDD net21 Y VDD P l=0.18u w=0.9u
.ends DLY1X1
*.SCALE meter
.GLOBAL GND VSS VDD

.subckt DLY2X1 Y A
M0 net18 net28 VSS VSS N l=0.36u w=0.28u
M1 net21 net18 VSS VSS N l=0.36u w=0.28u
M2 net18 net28 VDD VDD P l=0.36u w=0.42u
M3 net21 net18 VDD VDD P l=0.36u w=0.42u
M4 net28 A VSS VSS N l=0.18u w=0.28u
M5 VDD A net28 VDD P l=0.18u w=0.42u
M6 Y net21 VSS VSS N l=0.18u w=0.6u
M7 VDD net21 Y VDD P l=0.18u w=0.9u
.ends DLY2X1
*.SCALE meter
.GLOBAL GND VSS VDD

.subckt DLY3X1 Y A
M0 net18 net28 VSS VSS N l=0.54u w=0.28u
M1 net21 net18 VSS VSS N l=0.54u w=0.28u
M2 net18 net28 VDD VDD P l=0.54u w=0.42u
M3 net21 net18 VDD VDD P l=0.54u w=0.42u
M4 net28 A VSS VSS N l=0.18u w=0.28u
M5 VDD A net28 VDD P l=0.18u w=0.42u
M6 Y net21 VSS VSS N l=0.18u w=0.6u
M7 VDD net21 Y VDD P l=0.18u w=0.9u
.ends DLY3X1
*.SCALE meter
.GLOBAL GND VSS VDD

.subckt DLY4X1 Y A
M0 net18 net28 VSS VSS N l=0.72u w=0.28u
M1 net21 net18 VSS VSS N l=0.72u w=0.28u
M2 net18 net28 VDD VDD P l=0.72u w=0.42u
M3 net21 net18 VDD VDD P l=0.72u w=0.42u
M4 net28 A VSS VSS N l=0.18u w=0.28u
M5 VDD A net28 VDD P l=0.18u w=0.42u
M6 Y net21 VSS VSS N l=0.18u w=0.6u
M7 VDD net21 Y VDD P l=0.18u w=0.9u
.ends DLY4X1
*.SCALE meter
.GLOBAL GND VSS VDD

.subckt EDFFTRX1 Q QN CK D E RN
M0 net72 RN VSS VSS N l=0.18u w=0.3u
M1 net67 net98 net72 VSS N l=0.18u w=0.3u
M2 net76 s net67 VSS N l=0.18u w=0.3u
M3 net73 E net72 VSS N l=0.18u w=0.3u
M4 net76 D net73 VSS N l=0.18u w=0.3u
M5 net79 cn net76 VSS N l=0.18u w=0.3u
M6 net90 E VDD VDD P l=0.18u w=0.3u
M7 net87 net98 VDD VDD P l=0.18u w=0.3u
M8 net88 D net87 VDD P l=0.18u w=0.3u
M9 net88 s net90 VDD P l=0.18u w=0.3u
M10 net79 c net88 VDD P l=0.18u w=0.3u
M11 net88 RN VDD VDD P l=0.18u w=0.3u
M12 net98 E VSS VSS N l=0.18u w=0.3u
M13 VDD E net98 VDD P l=0.18u w=0.42u
M14 Q net113 VSS VSS N l=0.18u w=0.6u
M15 VDD net113 Q VDD P l=0.18u w=0.9u
M16 QN s VSS VSS N l=0.18u w=0.6u
M17 VDD s QN VDD P l=0.18u w=0.9u
M18 s net113 VSS VSS N l=0.18u w=0.4u
M19 VDD net113 s VDD P l=0.18u w=0.6u
M20 m net79 VSS VSS N l=0.18u w=0.3u
M21 VDD net79 m VDD P l=0.18u w=0.44u
M22 c cn VSS VSS N l=0.18u w=0.3u
M23 VDD cn c VDD P l=0.18u w=0.42u
M24 cn CK VSS VSS N l=0.18u w=0.46u
M25 VDD CK cn VDD P l=0.18u w=0.68u
M26 hnet42 cn net113 VDD P l=0.18u w=1.2u
M27 VDD m hnet42 VDD P l=0.18u w=1.2u
M28 hnet40 m VSS VSS N l=0.18u w=0.8u
M29 net113 c hnet40 VSS N l=0.18u w=0.8u
M30 hnet48 c net113 VDD P l=0.18u w=0.3u
M31 VDD s hnet48 VDD P l=0.18u w=0.3u
M32 hnet46 s VSS VSS N l=0.18u w=0.3u
M33 net113 cn hnet46 VSS N l=0.18u w=0.3u
M34 hnet54 cn net79 VDD P l=0.18u w=0.42u
M35 VDD m hnet54 VDD P l=0.18u w=0.42u
M36 hnet52 m VSS VSS N l=0.18u w=0.3u
M37 net79 c hnet52 VSS N l=0.18u w=0.3u
.ends EDFFTRX1
*.SCALE meter
.GLOBAL GND VSS VDD

.subckt EDFFTRX2 Q QN CK D E RN
M0 hnet26 cn net63 VDD P l=0.18u w=1.14u
M1 hnet29 cn net63 VDD P l=0.18u w=1.14u
M2 VDD m hnet26 VDD P l=0.18u w=1.14u
M3 VDD m hnet29 VDD P l=0.18u w=1.14u
M4 hnet30 m VSS VSS N l=0.18u w=1.36u
M5 net63 c hnet30 VSS N l=0.18u w=1.36u
M6 net76 RN VSS VSS N l=0.18u w=0.34u
M7 net71 net102 net76 VSS N l=0.18u w=0.34u
M8 net80 s net71 VSS N l=0.18u w=0.34u
M9 net77 E net76 VSS N l=0.18u w=0.34u
M10 net80 D net77 VSS N l=0.18u w=0.34u
M11 net83 cn net80 VSS N l=0.18u w=0.34u
M12 net94 E VDD VDD P l=0.18u w=0.46u
M13 net91 net102 VDD VDD P l=0.18u w=0.46u
M14 net92 D net91 VDD P l=0.18u w=0.46u
M15 net92 s net94 VDD P l=0.18u w=0.46u
M16 net83 c net92 VDD P l=0.18u w=0.46u
M17 net92 RN VDD VDD P l=0.18u w=0.4u
M18 net102 E VSS VSS N l=0.18u w=0.3u
M19 VDD E net102 VDD P l=0.18u w=0.42u
M20 Q net63 VSS VSS N l=0.18u w=1.2u
M21 VDD net63 Q VDD P l=0.18u w=1.67u
M22 QN s VSS VSS N l=0.18u w=1.2u
M23 VDD s QN VDD P l=0.18u w=1.67u
M24 s net63 VSS VSS N l=0.18u w=0.7u
M25 VDD net63 s VDD P l=0.18u w=1.04u
M26 m net83 VSS VSS N l=0.18u w=0.5u
M27 VDD net83 m VDD P l=0.18u w=0.76u
M28 c cn VSS VSS N l=0.18u w=0.4u
M29 VDD cn c VDD P l=0.18u w=0.6u
M30 cn CK VSS VSS N l=0.18u w=0.68u
M31 VDD CK cn VDD P l=0.18u w=1.02u
M32 hnet49 c net63 VDD P l=0.18u w=0.3u
M33 VDD s hnet49 VDD P l=0.18u w=0.3u
M34 hnet47 s VSS VSS N l=0.18u w=0.3u
M35 net63 cn hnet47 VSS N l=0.18u w=0.3u
M36 hnet55 cn net83 VDD P l=0.18u w=0.42u
M37 VDD m hnet55 VDD P l=0.18u w=0.42u
M38 hnet53 m VSS VSS N l=0.18u w=0.3u
M39 net83 c hnet53 VSS N l=0.18u w=0.3u
.ends EDFFTRX2
*.SCALE meter
.GLOBAL GND VSS VDD

.subckt EDFFTRX4 Q QN CK D E RN
M0 hnet28 cn net63 VDD P l=0.18u w=1.46u
M1 hnet30 cn net63 VDD P l=0.18u w=1.46u
M2 hnet27 cn net63 VDD P l=0.18u w=1.46u
M3 VDD m hnet28 VDD P l=0.18u w=1.46u
M4 VDD m hnet30 VDD P l=0.18u w=1.46u
M5 VDD m hnet27 VDD P l=0.18u w=1.46u
M6 hnet26 m VSS VSS N l=0.18u w=0.98u
M7 hnet29 m VSS VSS N l=0.18u w=0.98u
M8 hnet33 m VSS VSS N l=0.18u w=0.98u
M9 net63 c hnet26 VSS N l=0.18u w=0.98u
M10 net63 c hnet29 VSS N l=0.18u w=0.98u
M11 net63 c hnet33 VSS N l=0.18u w=0.98u
M12 net76 RN VSS VSS N l=0.18u w=0.62u
M13 net71 net102 net76 VSS N l=0.18u w=0.62u
M14 net80 s net71 VSS N l=0.18u w=0.62u
M15 net77 E net76 VSS N l=0.18u w=0.62u
M16 net80 D net77 VSS N l=0.18u w=0.62u
M17 net83 cn net80 VSS N l=0.18u w=0.62u
M18 net94 E VDD VDD P l=0.18u w=0.84u
M19 net91 net102 VDD VDD P l=0.18u w=0.84u
M20 net92 D net91 VDD P l=0.18u w=0.84u
M21 net92 s net94 VDD P l=0.18u w=0.84u
M22 net83 c net92 VDD P l=0.18u w=0.84u
M23 net92 RN VDD VDD P l=0.18u w=0.72u
M24 net102 E VSS VSS N l=0.18u w=0.3u
M25 VDD E net102 VDD P l=0.18u w=0.42u
M26 Q net63 VSS VSS N l=0.18u w=2.4u
M27 VDD net63 Q VDD P l=0.18u w=3.52u
M28 QN s VSS VSS N l=0.18u w=2.4u
M29 VDD s QN VDD P l=0.18u w=3.52u
M30 s net63 VSS VSS N l=0.18u w=1.26u
M31 VDD net63 s VDD P l=0.18u w=1.84u
M32 m net83 VSS VSS N l=0.18u w=0.92u
M33 VDD net83 m VDD P l=0.18u w=1.34u
M34 c cn VSS VSS N l=0.18u w=0.68u
M35 VDD cn c VDD P l=0.18u w=1.02u
M36 cn CK VSS VSS N l=0.18u w=1.15u
M37 VDD CK cn VDD P l=0.18u w=1.73u
M38 hnet52 c net63 VDD P l=0.18u w=0.3u
M39 VDD s hnet52 VDD P l=0.18u w=0.3u
M40 hnet50 s VSS VSS N l=0.18u w=0.3u
M41 net63 cn hnet50 VSS N l=0.18u w=0.3u
M42 hnet58 cn net83 VDD P l=0.18u w=0.42u
M43 VDD m hnet58 VDD P l=0.18u w=0.42u
M44 hnet56 m VSS VSS N l=0.18u w=0.3u
M45 net83 c hnet56 VSS N l=0.18u w=0.3u
.ends EDFFTRX4
*.SCALE meter
.GLOBAL GND VSS VDD

.subckt EDFFTRXL Q QN CK D E RN
M0 net72 RN VSS VSS N l=0.18u w=0.44u
M1 net67 net98 net72 VSS N l=0.18u w=0.48u
M2 net76 s net67 VSS N l=0.18u w=0.48u
M3 net73 E net72 VSS N l=0.18u w=0.48u
M4 net76 D net73 VSS N l=0.18u w=0.48u
M5 net79 cn net76 VSS N l=0.18u w=0.48u
M6 net90 E VDD VDD P l=0.18u w=0.66u
M7 net87 net98 VDD VDD P l=0.18u w=0.66u
M8 net88 D net87 VDD P l=0.18u w=0.66u
M9 net88 s net90 VDD P l=0.18u w=0.66u
M10 net79 c net88 VDD P l=0.18u w=0.66u
M11 net88 RN VDD VDD P l=0.18u w=0.52u
M12 net98 E VSS VSS N l=0.18u w=0.3u
M13 VDD E net98 VDD P l=0.18u w=0.44u
M14 Q net113 VSS VSS N l=0.18u w=0.46u
M15 VDD net113 Q VDD P l=0.18u w=0.64u
M16 QN s VSS VSS N l=0.18u w=0.42u
M17 VDD s QN VDD P l=0.18u w=0.64u
M18 s net113 VSS VSS N l=0.18u w=0.3u
M19 VDD net113 s VDD P l=0.18u w=0.46u
M20 m net79 VSS VSS N l=0.18u w=0.3u
M21 VDD net79 m VDD P l=0.18u w=0.42u
M22 c cn VSS VSS N l=0.18u w=0.3u
M23 VDD cn c VDD P l=0.18u w=0.42u
M24 cn CK VSS VSS N l=0.18u w=0.3u
M25 VDD CK cn VDD P l=0.18u w=0.42u
M26 hnet42 cn net113 VDD P l=0.18u w=0.84u
M27 VDD m hnet42 VDD P l=0.18u w=0.84u
M28 hnet40 m VSS VSS N l=0.18u w=0.56u
M29 net113 c hnet40 VSS N l=0.18u w=0.56u
M30 hnet48 c net113 VDD P l=0.18u w=0.3u
M31 VDD s hnet48 VDD P l=0.18u w=0.3u
M32 hnet46 s VSS VSS N l=0.18u w=0.3u
M33 net113 cn hnet46 VSS N l=0.18u w=0.3u
M34 hnet54 cn net79 VDD P l=0.18u w=0.42u
M35 VDD m hnet54 VDD P l=0.18u w=0.42u
M36 hnet52 m VSS VSS N l=0.18u w=0.3u
M37 net79 c hnet52 VSS N l=0.18u w=0.3u
.ends EDFFTRXL
*.SCALE meter
.GLOBAL GND VSS VDD

.subckt EDFFX1 Q QN CK D E
M0 net58 net86 VSS VSS N l=0.18u w=0.3u
M1 net67 s net58 VSS N l=0.18u w=0.3u
M2 net64 E VSS VSS N l=0.18u w=0.3u
M3 net67 D net64 VSS N l=0.18u w=0.3u
M4 net70 cn net67 VSS N l=0.18u w=0.3u
M5 net81 E VDD VDD P l=0.18u w=0.3u
M6 net78 net86 VDD VDD P l=0.18u w=0.3u
M7 net79 D net78 VDD P l=0.18u w=0.3u
M8 net79 s net81 VDD P l=0.18u w=0.3u
M9 net70 c net79 VDD P l=0.18u w=0.3u
M10 net86 E VSS VSS N l=0.18u w=0.3u
M11 VDD E net86 VDD P l=0.18u w=0.42u
M12 Q net101 VSS VSS N l=0.18u w=0.54u
M13 VDD net101 Q VDD P l=0.18u w=0.8u
M14 QN s VSS VSS N l=0.18u w=0.6u
M15 VDD s QN VDD P l=0.18u w=0.9u
M16 s net101 VSS VSS N l=0.18u w=0.4u
M17 VDD net101 s VDD P l=0.18u w=0.6u
M18 m net70 VSS VSS N l=0.18u w=0.3u
M19 VDD net70 m VDD P l=0.18u w=0.44u
M20 c cn VSS VSS N l=0.18u w=0.3u
M21 VDD cn c VDD P l=0.18u w=0.42u
M22 cn CK VSS VSS N l=0.18u w=0.46u
M23 VDD CK cn VDD P l=0.18u w=0.68u
M24 hnet40 cn net101 VDD P l=0.18u w=1.2u
M25 VDD m hnet40 VDD P l=0.18u w=1.2u
M26 hnet38 m VSS VSS N l=0.18u w=0.8u
M27 net101 c hnet38 VSS N l=0.18u w=0.8u
M28 hnet46 c net101 VDD P l=0.18u w=0.3u
M29 VDD s hnet46 VDD P l=0.18u w=0.3u
M30 hnet44 s VSS VSS N l=0.18u w=0.3u
M31 net101 cn hnet44 VSS N l=0.18u w=0.3u
M32 hnet52 cn net70 VDD P l=0.18u w=0.42u
M33 VDD m hnet52 VDD P l=0.18u w=0.42u
M34 hnet50 m VSS VSS N l=0.18u w=0.3u
M35 net70 c hnet50 VSS N l=0.18u w=0.3u
.ends EDFFX1
*.SCALE meter
.GLOBAL GND VSS VDD

.subckt EDFFX2 Q QN CK D E
M0 hnet30 cn net57 VDD P l=0.18u w=1.14u
M1 hnet28 cn net57 VDD P l=0.18u w=1.14u
M2 VDD m hnet30 VDD P l=0.18u w=1.14u
M3 VDD m hnet28 VDD P l=0.18u w=1.14u
M4 hnet24 m VSS VSS N l=0.18u w=0.72u
M5 hnet25 m VSS VSS N l=0.18u w=0.72u
M6 net57 c hnet24 VSS N l=0.18u w=0.72u
M7 net57 c hnet25 VSS N l=0.18u w=0.72u
M8 net62 net90 VSS VSS N l=0.18u w=0.32u
M9 net71 s net62 VSS N l=0.18u w=0.32u
M10 net68 E VSS VSS N l=0.18u w=0.32u
M11 net71 D net68 VSS N l=0.18u w=0.32u
M12 net74 cn net71 VSS N l=0.18u w=0.32u
M13 net85 E VDD VDD P l=0.18u w=0.46u
M14 net82 net90 VDD VDD P l=0.18u w=0.46u
M15 net83 D net82 VDD P l=0.18u w=0.46u
M16 net83 s net85 VDD P l=0.18u w=0.46u
M17 net74 c net83 VDD P l=0.18u w=0.46u
M18 net90 E VSS VSS N l=0.18u w=0.3u
M19 VDD E net90 VDD P l=0.18u w=0.46u
M20 Q net57 VSS VSS N l=0.18u w=1.17u
M21 VDD net57 Q VDD P l=0.18u w=1.79u
M22 QN s VSS VSS N l=0.18u w=1.17u
M23 VDD s QN VDD P l=0.18u w=1.79u
M24 s net57 VSS VSS N l=0.18u w=0.68u
M25 VDD net57 s VDD P l=0.18u w=1.02u
M26 m net74 VSS VSS N l=0.18u w=0.5u
M27 VDD net74 m VDD P l=0.18u w=0.76u
M28 c cn VSS VSS N l=0.18u w=0.42u
M29 VDD cn c VDD P l=0.18u w=0.6u
M30 cn CK VSS VSS N l=0.18u w=0.68u
M31 VDD CK cn VDD P l=0.18u w=1.02u
M32 hnet48 c net57 VDD P l=0.18u w=0.3u
M33 VDD s hnet48 VDD P l=0.18u w=0.3u
M34 hnet46 s VSS VSS N l=0.18u w=0.3u
M35 net57 cn hnet46 VSS N l=0.18u w=0.3u
M36 hnet54 cn net74 VDD P l=0.18u w=0.42u
M37 VDD m hnet54 VDD P l=0.18u w=0.42u
M38 hnet52 m VSS VSS N l=0.18u w=0.3u
M39 net74 c hnet52 VSS N l=0.18u w=0.3u
.ends EDFFX2
*.SCALE meter
.GLOBAL GND VSS VDD

.subckt EDFFX4 Q QN CK D E
M0 hnet26 cn net57 VDD P l=0.18u w=1.44u
M1 hnet28 cn net57 VDD P l=0.18u w=1.44u
M2 hnet25 cn net57 VDD P l=0.18u w=1.44u
M3 VDD m hnet26 VDD P l=0.18u w=1.44u
M4 VDD m hnet28 VDD P l=0.18u w=1.44u
M5 VDD m hnet25 VDD P l=0.18u w=1.44u
M6 hnet24 m VSS VSS N l=0.18u w=0.96u
M7 hnet27 m VSS VSS N l=0.18u w=0.96u
M8 hnet31 m VSS VSS N l=0.18u w=0.96u
M9 net57 c hnet24 VSS N l=0.18u w=0.96u
M10 net57 c hnet27 VSS N l=0.18u w=0.96u
M11 net57 c hnet31 VSS N l=0.18u w=0.96u
M12 net62 net90 VSS VSS N l=0.18u w=0.56u
M13 net71 s net62 VSS N l=0.18u w=0.56u
M14 net68 E VSS VSS N l=0.18u w=0.56u
M15 net71 D net68 VSS N l=0.18u w=0.56u
M16 net74 cn net71 VSS N l=0.18u w=0.56u
M17 net85 E VDD VDD P l=0.18u w=0.82u
M18 net82 net90 VDD VDD P l=0.18u w=0.82u
M19 net83 D net82 VDD P l=0.18u w=0.82u
M20 net83 s net85 VDD P l=0.18u w=0.82u
M21 net74 c net83 VDD P l=0.18u w=0.82u
M22 net90 E VSS VSS N l=0.18u w=0.3u
M23 VDD E net90 VDD P l=0.18u w=0.46u
M24 Q net57 VSS VSS N l=0.18u w=2.4u
M25 VDD net57 Q VDD P l=0.18u w=3.52u
M26 QN s VSS VSS N l=0.18u w=2.4u
M27 VDD s QN VDD P l=0.18u w=3.52u
M28 s net57 VSS VSS N l=0.18u w=1.26u
M29 VDD net57 s VDD P l=0.18u w=1.88u
M30 m net74 VSS VSS N l=0.18u w=0.86u
M31 VDD net74 m VDD P l=0.18u w=1.32u
M32 c cn VSS VSS N l=0.18u w=0.68u
M33 VDD cn c VDD P l=0.18u w=1.02u
M34 cn CK VSS VSS N l=0.18u w=1.16u
M35 VDD CK cn VDD P l=0.18u w=1.74u
M36 hnet50 c net57 VDD P l=0.18u w=0.3u
M37 VDD s hnet50 VDD P l=0.18u w=0.3u
M38 hnet48 s VSS VSS N l=0.18u w=0.3u
M39 net57 cn hnet48 VSS N l=0.18u w=0.3u
M40 hnet56 cn net74 VDD P l=0.18u w=0.42u
M41 VDD m hnet56 VDD P l=0.18u w=0.42u
M42 hnet54 m VSS VSS N l=0.18u w=0.3u
M43 net74 c hnet54 VSS N l=0.18u w=0.3u
.ends EDFFX4
*.SCALE meter
.GLOBAL GND VSS VDD

.subckt EDFFXL Q QN CK D E
M0 net58 net86 VSS VSS N l=0.18u w=0.44u
M1 net67 s net58 VSS N l=0.18u w=0.44u
M2 net64 E VSS VSS N l=0.18u w=0.44u
M3 net67 D net64 VSS N l=0.18u w=0.44u
M4 net70 cn net67 VSS N l=0.18u w=0.44u
M5 net81 E VDD VDD P l=0.18u w=0.66u
M6 net78 net86 VDD VDD P l=0.18u w=0.66u
M7 net79 D net78 VDD P l=0.18u w=0.66u
M8 net79 s net81 VDD P l=0.18u w=0.66u
M9 net70 c net79 VDD P l=0.18u w=0.66u
M10 net86 E VSS VSS N l=0.18u w=0.3u
M11 VDD E net86 VDD P l=0.18u w=0.42u
M12 Q net101 VSS VSS N l=0.18u w=0.42u
M13 VDD net101 Q VDD P l=0.18u w=0.64u
M14 QN s VSS VSS N l=0.18u w=0.42u
M15 VDD s QN VDD P l=0.18u w=0.64u
M16 s net101 VSS VSS N l=0.18u w=0.3u
M17 VDD net101 s VDD P l=0.18u w=0.42u
M18 m net70 VSS VSS N l=0.18u w=0.3u
M19 VDD net70 m VDD P l=0.18u w=0.42u
M20 c cn VSS VSS N l=0.18u w=0.3u
M21 VDD cn c VDD P l=0.18u w=0.42u
M22 cn CK VSS VSS N l=0.18u w=0.3u
M23 VDD CK cn VDD P l=0.18u w=0.46u
M24 hnet40 cn net101 VDD P l=0.18u w=0.84u
M25 VDD m hnet40 VDD P l=0.18u w=0.84u
M26 hnet38 m VSS VSS N l=0.18u w=0.56u
M27 net101 c hnet38 VSS N l=0.18u w=0.56u
M28 hnet46 c net101 VDD P l=0.18u w=0.3u
M29 VDD s hnet46 VDD P l=0.18u w=0.3u
M30 hnet44 s VSS VSS N l=0.18u w=0.3u
M31 net101 cn hnet44 VSS N l=0.18u w=0.3u
M32 hnet52 cn net70 VDD P l=0.18u w=0.42u
M33 VDD m hnet52 VDD P l=0.18u w=0.42u
M34 hnet50 m VSS VSS N l=0.18u w=0.3u
M35 net70 c hnet50 VSS N l=0.18u w=0.3u
.ends EDFFXL
*.SCALE meter
.GLOBAL GND VSS VDD

.subckt HOLDX1 Y
M0 Y net16 net8 VSS N l=0.18u w=0.3u
M1 net8 net16 VSS VSS N l=0.18u w=0.3u
M2 Y net16 VDD VDD P l=0.18u w=0.3u
M3 net16 Y VSS VSS N l=0.18u w=0.3u
M4 VDD Y net16 VDD P l=0.18u w=0.42u
.ends HOLDX1
*.SCALE meter
.GLOBAL GND VSS VDD

.subckt INVX1 Y A
M0 Y A VSS VSS N l=0.18u w=0.6u
M1 VDD A Y VDD P l=0.18u w=0.9u
.ends INVX1
*.SCALE meter
.GLOBAL GND VSS VDD

.subckt INVX12 Y A
M0 net10 net7 VSS VSS N l=0.19u w=2.86u
M1 VDD net7 net10 VDD P l=0.18u w=4.28u
M2 net7 A VSS VSS N l=0.19u w=1.14u
M3 VDD A net7 VDD P l=0.18u w=1.72u
M4 Y net10 VSS VSS N l=0.19u w=7.2u
M5 VDD net10 Y VDD P l=0.18u w=10.8u
.ends INVX12
*.SCALE meter
.GLOBAL GND VSS VDD

.subckt INVX16 Y A
M0 net10 net7 VSS VSS N l=0.19u w=3.78u
M1 VDD net7 net10 VDD P l=0.18u w=5.34u
M2 net7 A VSS VSS N l=0.19u w=1.5u
M3 VDD A net7 VDD P l=0.18u w=2.2u
M4 Y net10 VSS VSS N l=0.19u w=9.6u
M5 VDD net10 Y VDD P l=0.18u w=14.4u
.ends INVX16
*.SCALE meter
.GLOBAL GND VSS VDD

.subckt INVX2 Y A
M0 Y A VSS VSS N l=0.18u w=1.2u
M1 VDD A Y VDD P l=0.18u w=1.8u
.ends INVX2
*.SCALE meter
.GLOBAL GND VSS VDD

.subckt INVX20 Y A
M0 net10 net7 VSS VSS N l=0.19u w=4.76u
M1 VDD net7 net10 VDD P l=0.18u w=7.12u
M2 net7 A VSS VSS N l=0.19u w=1.88u
M3 VDD A net7 VDD P l=0.18u w=2.82u
M4 Y net10 VSS VSS N l=0.19u w=12u
M5 VDD net10 Y VDD P l=0.18u w=17.99u
.ends INVX20
*.SCALE meter
.GLOBAL GND VSS VDD

.subckt INVX3 Y A
M0 Y A VSS VSS N l=0.18u w=1.8u
M1 VDD A Y VDD P l=0.18u w=2.7u
.ends INVX3
*.SCALE meter
.GLOBAL GND VSS VDD

.subckt INVX4 Y A
M0 Y A VSS VSS N l=0.18u w=2.4u
M1 VDD A Y VDD P l=0.18u w=3.48u
.ends INVX4
*.SCALE meter
.GLOBAL GND VSS VDD

.subckt INVX8 Y A
M0 Y A VSS VSS N l=0.19u w=4.8u
M1 VDD A Y VDD P l=0.18u w=7.2u
.ends INVX8
*.SCALE meter
.GLOBAL GND VSS VDD

.subckt INVXL Y A
M0 Y A VSS VSS N l=0.18u w=0.42u
M1 VDD A Y VDD P l=0.18u w=0.64u
.ends INVXL
*.SCALE meter
.GLOBAL GND VSS VDD

.subckt JKFFRX1 Q QN CK J K RN
M0 VDD net87 hnet25 VDD P l=0.18u w=0.92u
M1 hnet25 net98 s VDD P l=0.18u w=0.92u
M2 s net87 VSS VSS N l=0.18u w=0.46u
M3 s net98 VSS VSS N l=0.18u w=0.46u
M4 VDD net87 hnet29 VDD P l=0.18u w=0.56u
M5 hnet29 net102 m VDD P l=0.18u w=0.56u
M6 m net87 VSS VSS N l=0.18u w=0.3u
M7 m net102 VSS VSS N l=0.18u w=0.3u
M8 VDD outn hnet33 VDD P l=0.18u w=0.56u
M9 hnet33 K net54 VDD P l=0.18u w=0.56u
M10 net54 outn VSS VSS N l=0.18u w=0.3u
M11 net54 K VSS VSS N l=0.18u w=0.3u
M12 net59 outn net62 VSS N l=0.18u w=0.3u
M13 net62 J VSS VSS N l=0.18u w=0.3u
M14 net102 cn net59 VSS N l=0.18u w=0.3u
M15 net59 net54 VSS VSS N l=0.18u w=0.3u
M16 net76 net54 net80 VDD P l=0.18u w=0.32u
M17 net80 outn VDD VDD P l=0.18u w=0.32u
M18 net102 c net76 VDD P l=0.18u w=0.32u
M19 net80 J VDD VDD P l=0.18u w=0.32u
M20 Q outn VSS VSS N l=0.18u w=0.6u
M21 VDD outn Q VDD P l=0.18u w=0.9u
M22 QN s VSS VSS N l=0.18u w=0.57u
M23 VDD s QN VDD P l=0.18u w=0.9u
M24 outn s VSS VSS N l=0.18u w=0.32u
M25 VDD s outn VDD P l=0.18u w=0.48u
M26 net87 RN VSS VSS N l=0.18u w=0.36u
M27 VDD RN net87 VDD P l=0.18u w=0.54u
M28 c cn VSS VSS N l=0.18u w=0.3u
M29 VDD cn c VDD P l=0.18u w=0.42u
M30 cn CK VSS VSS N l=0.18u w=0.38u
M31 VDD CK cn VDD P l=0.18u w=0.56u
M32 hnet51 c net98 VDD P l=0.18u w=0.3u
M33 VDD s hnet51 VDD P l=0.18u w=0.3u
M34 hnet49 s VSS VSS N l=0.18u w=0.3u
M35 net98 cn hnet49 VSS N l=0.18u w=0.3u
M36 hnet57 cn net98 VDD P l=0.18u w=0.66u
M37 VDD m hnet57 VDD P l=0.18u w=0.66u
M38 hnet55 m VSS VSS N l=0.18u w=0.44u
M39 net98 c hnet55 VSS N l=0.18u w=0.44u
M40 hnet63 cn net102 VDD P l=0.18u w=0.42u
M41 VDD m hnet63 VDD P l=0.18u w=0.42u
M42 hnet61 m VSS VSS N l=0.18u w=0.3u
M43 net102 c hnet61 VSS N l=0.18u w=0.3u
.ends JKFFRX1
*.SCALE meter
.GLOBAL GND VSS VDD

.subckt JKFFRX2 Q QN CK J K RN
M0 VDD net87 hnet25 VDD P l=0.18u w=1.6u
M1 hnet25 net98 s VDD P l=0.18u w=1.6u
M2 s net87 VSS VSS N l=0.18u w=0.76u
M3 s net98 VSS VSS N l=0.18u w=0.76u
M4 VDD net87 hnet29 VDD P l=0.18u w=0.56u
M5 hnet29 net102 m VDD P l=0.18u w=0.56u
M6 m net87 VSS VSS N l=0.18u w=0.3u
M7 m net102 VSS VSS N l=0.18u w=0.3u
M8 VDD outn hnet33 VDD P l=0.18u w=0.56u
M9 hnet33 K net54 VDD P l=0.18u w=0.56u
M10 net54 outn VSS VSS N l=0.18u w=0.3u
M11 net54 K VSS VSS N l=0.18u w=0.3u
M12 net59 outn net62 VSS N l=0.18u w=0.3u
M13 net62 J VSS VSS N l=0.18u w=0.3u
M14 net102 cn net59 VSS N l=0.18u w=0.3u
M15 net59 net54 VSS VSS N l=0.18u w=0.3u
M16 net76 net54 net80 VDD P l=0.18u w=0.32u
M17 net80 outn VDD VDD P l=0.18u w=0.32u
M18 net102 c net76 VDD P l=0.18u w=0.32u
M19 net80 J VDD VDD P l=0.18u w=0.32u
M20 Q outn VSS VSS N l=0.18u w=1.2u
M21 VDD outn Q VDD P l=0.18u w=1.8u
M22 QN s VSS VSS N l=0.18u w=1.2u
M23 VDD s QN VDD P l=0.18u w=1.8u
M24 outn s VSS VSS N l=0.18u w=0.6u
M25 VDD s outn VDD P l=0.18u w=0.9u
M26 net87 RN VSS VSS N l=0.18u w=0.52u
M27 VDD RN net87 VDD P l=0.18u w=0.78u
M28 c cn VSS VSS N l=0.18u w=0.3u
M29 VDD cn c VDD P l=0.18u w=0.42u
M30 cn CK VSS VSS N l=0.18u w=0.44u
M31 VDD CK cn VDD P l=0.18u w=0.66u
M32 hnet51 c net98 VDD P l=0.18u w=0.3u
M33 VDD s hnet51 VDD P l=0.18u w=0.3u
M34 hnet49 s VSS VSS N l=0.18u w=0.3u
M35 net98 cn hnet49 VSS N l=0.18u w=0.3u
M36 hnet57 cn net98 VDD P l=0.18u w=1.14u
M37 VDD m hnet57 VDD P l=0.18u w=1.14u
M38 hnet55 m VSS VSS N l=0.18u w=0.72u
M39 net98 c hnet55 VSS N l=0.18u w=0.72u
M40 hnet63 cn net102 VDD P l=0.18u w=0.42u
M41 VDD m hnet63 VDD P l=0.18u w=0.42u
M42 hnet61 m VSS VSS N l=0.18u w=0.3u
M43 net102 c hnet61 VSS N l=0.18u w=0.3u
.ends JKFFRX2
*.SCALE meter
.GLOBAL GND VSS VDD

.subckt JKFFRX4 Q QN CK J K RN
M0 VDD net87 hnet26 VDD P l=0.18u w=1.48u
M1 hnet26 net94 s VDD P l=0.18u w=1.48u
M2 VDD net87 hnet24 VDD P l=0.18u w=1.48u
M3 hnet24 net94 s VDD P l=0.18u w=1.48u
M4 s net87 VSS VSS N l=0.18u w=1.3u
M5 s net94 VSS VSS N l=0.18u w=1.3u
M6 VDD net87 hnet30 VDD P l=0.18u w=0.96u
M7 hnet30 net102 m VDD P l=0.18u w=0.96u
M8 m net87 VSS VSS N l=0.18u w=0.48u
M9 m net102 VSS VSS N l=0.18u w=0.48u
M10 VDD outn hnet34 VDD P l=0.18u w=0.56u
M11 hnet34 K net54 VDD P l=0.18u w=0.56u
M12 net54 outn VSS VSS N l=0.18u w=0.3u
M13 net54 K VSS VSS N l=0.18u w=0.3u
M14 net59 outn net62 VSS N l=0.18u w=0.36u
M15 net62 J VSS VSS N l=0.18u w=0.36u
M16 net102 cn net59 VSS N l=0.18u w=0.36u
M17 net59 net54 VSS VSS N l=0.18u w=0.3u
M18 net71 net54 net80 VDD P l=0.18u w=0.54u
M19 net80 outn VDD VDD P l=0.18u w=0.54u
M20 net102 c net71 VDD P l=0.18u w=0.54u
M21 net80 J VDD VDD P l=0.18u w=0.54u
M22 Q outn VSS VSS N l=0.18u w=2.44u
M23 VDD outn Q VDD P l=0.18u w=3.6u
M24 QN s VSS VSS N l=0.18u w=2.44u
M25 VDD s QN VDD P l=0.18u w=3.6u
M26 outn s VSS VSS N l=0.18u w=1.16u
M27 VDD s outn VDD P l=0.18u w=1.77u
M28 net87 RN VSS VSS N l=0.18u w=0.92u
M29 VDD RN net87 VDD P l=0.18u w=1.4u
M30 c cn VSS VSS N l=0.18u w=0.4u
M31 VDD cn c VDD P l=0.18u w=0.6u
M32 cn CK VSS VSS N l=0.18u w=0.66u
M33 VDD CK cn VDD P l=0.18u w=1u
M34 hnet56 cn net94 VDD P l=0.18u w=1.08u
M35 hnet54 cn net94 VDD P l=0.18u w=1.08u
M36 VDD m hnet56 VDD P l=0.18u w=1.08u
M37 VDD m hnet54 VDD P l=0.18u w=1.08u
M38 hnet50 m VSS VSS N l=0.18u w=0.72u
M39 hnet51 m VSS VSS N l=0.18u w=0.72u
M40 net94 c hnet50 VSS N l=0.18u w=0.72u
M41 net94 c hnet51 VSS N l=0.18u w=0.72u
M42 hnet60 c net94 VDD P l=0.18u w=0.3u
M43 VDD s hnet60 VDD P l=0.18u w=0.3u
M44 hnet58 s VSS VSS N l=0.18u w=0.3u
M45 net94 cn hnet58 VSS N l=0.18u w=0.3u
M46 hnet66 cn net102 VDD P l=0.18u w=0.42u
M47 VDD m hnet66 VDD P l=0.18u w=0.42u
M48 hnet64 m VSS VSS N l=0.18u w=0.3u
M49 net102 c hnet64 VSS N l=0.18u w=0.3u
.ends JKFFRX4
*.SCALE meter
.GLOBAL GND VSS VDD

.subckt JKFFRXL Q QN CK J K RN
M0 VDD net87 hnet25 VDD P l=0.18u w=0.56u
M1 hnet25 net98 s VDD P l=0.18u w=0.56u
M2 s net87 VSS VSS N l=0.18u w=0.3u
M3 s net98 VSS VSS N l=0.18u w=0.3u
M4 VDD net87 hnet29 VDD P l=0.18u w=0.56u
M5 hnet29 net102 m VDD P l=0.18u w=0.56u
M6 m net87 VSS VSS N l=0.18u w=0.3u
M7 m net102 VSS VSS N l=0.18u w=0.3u
M8 VDD outn hnet33 VDD P l=0.18u w=0.56u
M9 hnet33 K net54 VDD P l=0.18u w=0.56u
M10 net54 outn VSS VSS N l=0.18u w=0.3u
M11 net54 K VSS VSS N l=0.18u w=0.3u
M12 net59 outn net62 VSS N l=0.18u w=0.44u
M13 net62 J VSS VSS N l=0.18u w=0.44u
M14 net102 cn net59 VSS N l=0.18u w=0.44u
M15 net59 net54 VSS VSS N l=0.18u w=0.36u
M16 net76 net54 net80 VDD P l=0.18u w=0.66u
M17 net80 outn VDD VDD P l=0.18u w=0.66u
M18 net102 c net76 VDD P l=0.18u w=0.66u
M19 net80 J VDD VDD P l=0.18u w=0.66u
M20 Q outn VSS VSS N l=0.18u w=0.42u
M21 VDD outn Q VDD P l=0.18u w=0.64u
M22 QN s VSS VSS N l=0.18u w=0.42u
M23 VDD s QN VDD P l=0.18u w=0.64u
M24 outn s VSS VSS N l=0.18u w=0.3u
M25 VDD s outn VDD P l=0.18u w=0.42u
M26 net87 RN VSS VSS N l=0.18u w=0.3u
M27 VDD RN net87 VDD P l=0.18u w=0.42u
M28 c cn VSS VSS N l=0.18u w=0.3u
M29 VDD cn c VDD P l=0.18u w=0.42u
M30 cn CK VSS VSS N l=0.18u w=0.3u
M31 VDD CK cn VDD P l=0.18u w=0.42u
M32 hnet51 c net98 VDD P l=0.18u w=0.3u
M33 VDD s hnet51 VDD P l=0.18u w=0.3u
M34 hnet49 s VSS VSS N l=0.18u w=0.3u
M35 net98 cn hnet49 VSS N l=0.18u w=0.3u
M36 hnet57 cn net98 VDD P l=0.18u w=0.84u
M37 VDD m hnet57 VDD P l=0.18u w=0.84u
M38 hnet55 m VSS VSS N l=0.18u w=0.56u
M39 net98 c hnet55 VSS N l=0.18u w=0.56u
M40 hnet63 cn net102 VDD P l=0.18u w=0.42u
M41 VDD m hnet63 VDD P l=0.18u w=0.42u
M42 hnet61 m VSS VSS N l=0.18u w=0.3u
M43 net102 c hnet61 VSS N l=0.18u w=0.3u
.ends JKFFRXL
*.SCALE meter
.GLOBAL GND VSS VDD

.subckt JKFFSRX1 Q QN CK J K RN SN
M0 VDD net146 hnet31 VDD P l=0.18u w=1u
M1 hnet31 net137 s VDD P l=0.18u w=1u
M2 VDD outn hnet33 VDD P l=0.18u w=0.56u
M3 hnet33 K net75 VDD P l=0.18u w=0.56u
M4 net75 outn VSS VSS N l=0.18u w=0.3u
M5 net75 K VSS VSS N l=0.18u w=0.3u
M6 net80 outn net83 VSS N l=0.18u w=0.3u
M7 net83 J VSS VSS N l=0.18u w=0.3u
M8 net141 cn net80 VSS N l=0.18u w=0.3u
M9 net80 net75 VSS VSS N l=0.18u w=0.3u
M10 s net146 net98 VSS N l=0.18u w=0.62u
M11 s net137 net98 VSS N l=0.18u w=0.62u
M12 net98 SN VSS VSS N l=0.18u w=0.62u
M13 m net146 net107 VSS N l=0.18u w=0.3u
M14 m net141 net107 VSS N l=0.18u w=0.3u
M15 net107 SN VSS VSS N l=0.18u w=0.3u
M16 net115 net75 net119 VDD P l=0.18u w=0.3u
M17 net119 outn VDD VDD P l=0.18u w=0.3u
M18 net141 c net115 VDD P l=0.18u w=0.3u
M19 net119 J VDD VDD P l=0.18u w=0.3u
M20 s SN VDD VDD P l=0.18u w=0.7u
M21 m SN VDD VDD P l=0.18u w=0.32u
M22 m net141 net127 VDD P l=0.18u w=0.42u
M23 net127 net146 VDD VDD P l=0.18u w=0.42u
M24 hnet39 cn net137 VDD P l=0.18u w=0.76u
M25 VDD m hnet39 VDD P l=0.18u w=0.76u
M26 hnet37 m VSS VSS N l=0.18u w=0.5u
M27 net137 c hnet37 VSS N l=0.18u w=0.5u
M28 hnet45 c net137 VDD P l=0.18u w=0.3u
M29 VDD s hnet45 VDD P l=0.18u w=0.3u
M30 hnet43 s VSS VSS N l=0.18u w=0.3u
M31 net137 cn hnet43 VSS N l=0.18u w=0.3u
M32 hnet51 cn net141 VDD P l=0.18u w=0.42u
M33 VDD m hnet51 VDD P l=0.18u w=0.42u
M34 hnet49 m VSS VSS N l=0.18u w=0.3u
M35 net141 c hnet49 VSS N l=0.18u w=0.3u
M36 Q outn VSS VSS N l=0.18u w=0.6u
M37 VDD outn Q VDD P l=0.18u w=0.9u
M38 net146 RN VSS VSS N l=0.18u w=0.36u
M39 VDD RN net146 VDD P l=0.18u w=0.54u
M40 c cn VSS VSS N l=0.18u w=0.3u
M41 VDD cn c VDD P l=0.18u w=0.42u
M42 cn CK VSS VSS N l=0.18u w=0.38u
M43 VDD CK cn VDD P l=0.18u w=0.56u
M44 QN s VSS VSS N l=0.18u w=0.53u
M45 VDD s QN VDD P l=0.18u w=0.8u
M46 outn s VSS VSS N l=0.18u w=0.46u
M47 VDD s outn VDD P l=0.18u w=0.68u
.ends JKFFSRX1
*.SCALE meter
.GLOBAL GND VSS VDD

.subckt JKFFSRX2 Q QN CK J K RN SN
M0 VDD net146 hnet31 VDD P l=0.18u w=1.62u
M1 hnet31 net137 s VDD P l=0.18u w=1.62u
M2 VDD outn hnet33 VDD P l=0.18u w=0.56u
M3 hnet33 K net75 VDD P l=0.18u w=0.56u
M4 net75 outn VSS VSS N l=0.18u w=0.3u
M5 net75 K VSS VSS N l=0.18u w=0.3u
M6 net80 outn net83 VSS N l=0.18u w=0.3u
M7 net83 J VSS VSS N l=0.18u w=0.3u
M8 net141 cn net80 VSS N l=0.18u w=0.3u
M9 net80 net75 VSS VSS N l=0.18u w=0.3u
M10 s net146 net98 VSS N l=0.18u w=0.78u
M11 s net137 net98 VSS N l=0.18u w=0.78u
M12 net98 SN VSS VSS N l=0.18u w=1.04u
M13 m net146 net107 VSS N l=0.18u w=0.42u
M14 m net141 net107 VSS N l=0.18u w=0.42u
M15 net107 SN VSS VSS N l=0.18u w=0.42u
M16 net115 net75 net119 VDD P l=0.18u w=0.4u
M17 net119 outn VDD VDD P l=0.18u w=0.4u
M18 net141 c net115 VDD P l=0.18u w=0.4u
M19 net119 J VDD VDD P l=0.18u w=0.4u
M20 s SN VDD VDD P l=0.18u w=1.22u
M21 m SN VDD VDD P l=0.18u w=0.48u
M22 m net141 net131 VDD P l=0.18u w=0.64u
M23 net131 net146 VDD VDD P l=0.18u w=0.64u
M24 hnet39 cn net137 VDD P l=0.18u w=1.08u
M25 VDD m hnet39 VDD P l=0.18u w=1.08u
M26 hnet37 m VSS VSS N l=0.18u w=0.54u
M27 net137 c hnet37 VSS N l=0.18u w=0.54u
M28 hnet45 c net137 VDD P l=0.18u w=0.3u
M29 VDD s hnet45 VDD P l=0.18u w=0.3u
M30 hnet43 s VSS VSS N l=0.18u w=0.3u
M31 net137 cn hnet43 VSS N l=0.18u w=0.3u
M32 hnet51 cn net141 VDD P l=0.18u w=0.42u
M33 VDD m hnet51 VDD P l=0.18u w=0.42u
M34 hnet49 m VSS VSS N l=0.18u w=0.3u
M35 net141 c hnet49 VSS N l=0.18u w=0.3u
M36 Q outn VSS VSS N l=0.18u w=1.2u
M37 VDD outn Q VDD P l=0.18u w=1.76u
M38 net146 RN VSS VSS N l=0.18u w=0.6u
M39 VDD RN net146 VDD P l=0.18u w=0.9u
M40 c cn VSS VSS N l=0.18u w=0.28u
M41 VDD cn c VDD P l=0.18u w=0.46u
M42 cn CK VSS VSS N l=0.18u w=0.46u
M43 VDD CK cn VDD P l=0.18u w=0.68u
M44 QN s VSS VSS N l=0.18u w=1.2u
M45 VDD s QN VDD P l=0.18u w=1.76u
M46 outn s VSS VSS N l=0.18u w=0.72u
M47 VDD s outn VDD P l=0.18u w=1.08u
.ends JKFFSRX2
*.SCALE meter
.GLOBAL GND VSS VDD

.subckt JKFFSRX4 Q QN CK J K RN SN
M0 VDD net146 hnet31 VDD P l=0.18u w=1.62u
M1 hnet31 net137 s VDD P l=0.18u w=1.62u
M2 VDD outn hnet33 VDD P l=0.18u w=0.56u
M3 hnet33 K net75 VDD P l=0.18u w=0.56u
M4 net75 outn VSS VSS N l=0.18u w=0.3u
M5 net75 K VSS VSS N l=0.18u w=0.3u
M6 net80 outn net83 VSS N l=0.18u w=0.3u
M7 net83 J VSS VSS N l=0.18u w=0.3u
M8 net141 cn net80 VSS N l=0.18u w=0.3u
M9 net80 net75 VSS VSS N l=0.18u w=0.3u
M10 s net146 net98 VSS N l=0.18u w=0.78u
M11 s net137 net98 VSS N l=0.18u w=0.78u
M12 net98 SN VSS VSS N l=0.18u w=1.04u
M13 m net146 net107 VSS N l=0.18u w=0.42u
M14 m net141 net107 VSS N l=0.18u w=0.42u
M15 net107 SN VSS VSS N l=0.18u w=0.42u
M16 net115 net75 net119 VDD P l=0.18u w=0.4u
M17 net119 outn VDD VDD P l=0.18u w=0.4u
M18 net141 c net115 VDD P l=0.18u w=0.4u
M19 net119 J VDD VDD P l=0.18u w=0.4u
M20 s SN VDD VDD P l=0.18u w=1.22u
M21 m SN VDD VDD P l=0.18u w=0.48u
M22 m net141 net131 VDD P l=0.18u w=0.64u
M23 net131 net146 VDD VDD P l=0.18u w=0.64u
M24 hnet39 cn net137 VDD P l=0.18u w=1.08u
M25 VDD m hnet39 VDD P l=0.18u w=1.08u
M26 hnet37 m VSS VSS N l=0.18u w=0.54u
M27 net137 c hnet37 VSS N l=0.18u w=0.54u
M28 hnet45 c net137 VDD P l=0.18u w=0.3u
M29 VDD s hnet45 VDD P l=0.18u w=0.3u
M30 hnet43 s VSS VSS N l=0.18u w=0.3u
M31 net137 cn hnet43 VSS N l=0.18u w=0.3u
M32 hnet51 cn net141 VDD P l=0.18u w=0.42u
M33 VDD m hnet51 VDD P l=0.18u w=0.42u
M34 hnet49 m VSS VSS N l=0.18u w=0.3u
M35 net141 c hnet49 VSS N l=0.18u w=0.3u
M36 Q outn VSS VSS N l=0.18u w=2.48u
M37 VDD outn Q VDD P l=0.18u w=3.58u
M38 net146 RN VSS VSS N l=0.18u w=0.6u
M39 VDD RN net146 VDD P l=0.18u w=0.9u
M40 c cn VSS VSS N l=0.18u w=0.28u
M41 VDD cn c VDD P l=0.18u w=0.46u
M42 cn CK VSS VSS N l=0.18u w=0.46u
M43 VDD CK cn VDD P l=0.18u w=0.68u
M44 QN s VSS VSS N l=0.18u w=2.48u
M45 VDD s QN VDD P l=0.18u w=3.58u
M46 outn s VSS VSS N l=0.18u w=1u
M47 VDD s outn VDD P l=0.18u w=1.4u
.ends JKFFSRX4
*.SCALE meter
.GLOBAL GND VSS VDD

.subckt JKFFSRXL Q QN CK J K RN SN
M0 VDD net146 hnet31 VDD P l=0.18u w=0.56u
M1 hnet31 net137 s VDD P l=0.18u w=0.56u
M2 VDD outn hnet33 VDD P l=0.18u w=0.56u
M3 hnet33 K net75 VDD P l=0.18u w=0.56u
M4 net75 outn VSS VSS N l=0.18u w=0.3u
M5 net75 K VSS VSS N l=0.18u w=0.3u
M6 net80 outn net83 VSS N l=0.18u w=0.44u
M7 net83 J VSS VSS N l=0.18u w=0.44u
M8 net141 cn net80 VSS N l=0.18u w=0.44u
M9 net80 net75 VSS VSS N l=0.18u w=0.36u
M10 s net146 net98 VSS N l=0.18u w=0.36u
M11 s net137 net98 VSS N l=0.18u w=0.36u
M12 net98 SN VSS VSS N l=0.18u w=0.36u
M13 m net146 net107 VSS N l=0.18u w=0.36u
M14 m net141 net107 VSS N l=0.18u w=0.36u
M15 net107 SN VSS VSS N l=0.18u w=0.36u
M16 net115 net75 net119 VDD P l=0.18u w=0.66u
M17 net119 outn VDD VDD P l=0.18u w=0.66u
M18 net141 c net115 VDD P l=0.18u w=0.66u
M19 net119 J VDD VDD P l=0.18u w=0.66u
M20 s SN VDD VDD P l=0.18u w=0.46u
M21 m SN VDD VDD P l=0.18u w=0.42u
M22 m net141 net131 VDD P l=0.18u w=0.56u
M23 net131 net146 VDD VDD P l=0.18u w=0.56u
M24 hnet39 cn net137 VDD P l=0.18u w=0.84u
M25 VDD m hnet39 VDD P l=0.18u w=0.84u
M26 hnet37 m VSS VSS N l=0.18u w=0.54u
M27 net137 c hnet37 VSS N l=0.18u w=0.54u
M28 hnet45 c net137 VDD P l=0.18u w=0.3u
M29 VDD s hnet45 VDD P l=0.18u w=0.3u
M30 hnet43 s VSS VSS N l=0.18u w=0.3u
M31 net137 cn hnet43 VSS N l=0.18u w=0.3u
M32 hnet51 cn net141 VDD P l=0.18u w=0.42u
M33 VDD m hnet51 VDD P l=0.18u w=0.42u
M34 hnet49 m VSS VSS N l=0.18u w=0.3u
M35 net141 c hnet49 VSS N l=0.18u w=0.3u
M36 Q outn VSS VSS N l=0.18u w=0.42u
M37 VDD outn Q VDD P l=0.18u w=0.64u
M38 net146 RN VSS VSS N l=0.18u w=0.3u
M39 VDD RN net146 VDD P l=0.18u w=0.42u
M40 c cn VSS VSS N l=0.18u w=0.3u
M41 VDD cn c VDD P l=0.18u w=0.42u
M42 cn CK VSS VSS N l=0.18u w=0.3u
M43 VDD CK cn VDD P l=0.18u w=0.42u
M44 QN s VSS VSS N l=0.18u w=0.42u
M45 VDD s QN VDD P l=0.18u w=0.64u
M46 outn s VSS VSS N l=0.18u w=0.3u
M47 VDD s outn VDD P l=0.18u w=0.42u
.ends JKFFSRXL
*.SCALE meter
.GLOBAL GND VSS VDD

.subckt JKFFSX1 Q QN CK J K SN
M0 VDD SN s VDD P l=0.18u w=0.78u
M1 VDD net94 s VDD P l=0.18u w=0.78u
M2 hnet26 SN VSS VSS N l=0.18u w=0.68u
M3 s net94 hnet26 VSS N l=0.18u w=0.68u
M4 VDD SN m VDD P l=0.18u w=0.32u
M5 VDD net98 m VDD P l=0.18u w=0.32u
M6 hnet30 SN VSS VSS N l=0.18u w=0.3u
M7 m net98 hnet30 VSS N l=0.18u w=0.3u
M8 VDD outn hnet32 VDD P l=0.18u w=0.56u
M9 hnet32 K net52 VDD P l=0.18u w=0.56u
M10 net52 outn VSS VSS N l=0.18u w=0.3u
M11 net52 K VSS VSS N l=0.18u w=0.3u
M12 net57 outn net60 VSS N l=0.18u w=0.3u
M13 net60 J VSS VSS N l=0.18u w=0.3u
M14 net98 cn net57 VSS N l=0.18u w=0.3u
M15 net57 net52 VSS VSS N l=0.18u w=0.3u
M16 net74 net52 net78 VDD P l=0.18u w=0.3u
M17 net78 outn VDD VDD P l=0.18u w=0.3u
M18 net98 c net74 VDD P l=0.18u w=0.3u
M19 net78 J VDD VDD P l=0.18u w=0.3u
M20 Q outn VSS VSS N l=0.18u w=0.6u
M21 VDD outn Q VDD P l=0.18u w=0.9u
M22 QN s VSS VSS N l=0.18u w=0.58u
M23 VDD s QN VDD P l=0.18u w=0.86u
M24 outn s VSS VSS N l=0.18u w=0.46u
M25 VDD s outn VDD P l=0.18u w=0.68u
M26 c cn VSS VSS N l=0.18u w=0.3u
M27 VDD cn c VDD P l=0.18u w=0.42u
M28 cn CK VSS VSS N l=0.18u w=0.38u
M29 VDD CK cn VDD P l=0.18u w=0.56u
M30 hnet48 cn net94 VDD P l=0.18u w=0.68u
M31 VDD m hnet48 VDD P l=0.18u w=0.68u
M32 hnet46 m VSS VSS N l=0.18u w=0.46u
M33 net94 c hnet46 VSS N l=0.18u w=0.46u
M34 hnet54 c net94 VDD P l=0.18u w=0.3u
M35 VDD s hnet54 VDD P l=0.18u w=0.3u
M36 hnet52 s VSS VSS N l=0.18u w=0.3u
M37 net94 cn hnet52 VSS N l=0.18u w=0.3u
M38 hnet60 cn net98 VDD P l=0.18u w=0.42u
M39 VDD m hnet60 VDD P l=0.18u w=0.42u
M40 hnet58 m VSS VSS N l=0.18u w=0.3u
M41 net98 c hnet58 VSS N l=0.18u w=0.3u
.ends JKFFSX1
*.SCALE meter
.GLOBAL GND VSS VDD

.subckt JKFFSX2 Q QN CK J K SN
M0 VDD SN s VDD P l=0.18u w=1.2u
M1 VDD net94 s VDD P l=0.18u w=1.2u
M2 hnet26 SN VSS VSS N l=0.18u w=1.06u
M3 s net94 hnet26 VSS N l=0.18u w=1.06u
M4 VDD SN m VDD P l=0.18u w=0.4u
M5 VDD net98 m VDD P l=0.18u w=0.4u
M6 hnet30 SN VSS VSS N l=0.18u w=0.36u
M7 m net98 hnet30 VSS N l=0.18u w=0.36u
M8 VDD outn hnet32 VDD P l=0.18u w=0.56u
M9 hnet32 K net52 VDD P l=0.18u w=0.56u
M10 net52 outn VSS VSS N l=0.18u w=0.3u
M11 net52 K VSS VSS N l=0.18u w=0.3u
M12 net57 outn net60 VSS N l=0.18u w=0.3u
M13 net60 J VSS VSS N l=0.18u w=0.3u
M14 net98 cn net57 VSS N l=0.18u w=0.3u
M15 net57 net52 VSS VSS N l=0.18u w=0.3u
M16 net74 net52 net78 VDD P l=0.18u w=0.3u
M17 net78 outn VDD VDD P l=0.18u w=0.3u
M18 net98 c net74 VDD P l=0.18u w=0.3u
M19 net78 J VDD VDD P l=0.18u w=0.3u
M20 Q outn VSS VSS N l=0.18u w=1.2u
M21 VDD outn Q VDD P l=0.18u w=1.73u
M22 QN s VSS VSS N l=0.18u w=1.2u
M23 VDD s QN VDD P l=0.18u w=1.73u
M24 outn s VSS VSS N l=0.18u w=0.58u
M25 VDD s outn VDD P l=0.18u w=0.88u
M26 c cn VSS VSS N l=0.18u w=0.3u
M27 VDD cn c VDD P l=0.18u w=0.42u
M28 cn CK VSS VSS N l=0.18u w=0.44u
M29 VDD CK cn VDD P l=0.18u w=0.66u
M30 hnet48 cn net94 VDD P l=0.18u w=1.08u
M31 VDD m hnet48 VDD P l=0.18u w=1.08u
M32 hnet46 m VSS VSS N l=0.18u w=0.72u
M33 net94 c hnet46 VSS N l=0.18u w=0.72u
M34 hnet54 c net94 VDD P l=0.18u w=0.3u
M35 VDD s hnet54 VDD P l=0.18u w=0.3u
M36 hnet52 s VSS VSS N l=0.18u w=0.3u
M37 net94 cn hnet52 VSS N l=0.18u w=0.3u
M38 hnet60 cn net98 VDD P l=0.18u w=0.42u
M39 VDD m hnet60 VDD P l=0.18u w=0.42u
M40 hnet58 m VSS VSS N l=0.18u w=0.3u
M41 net98 c hnet58 VSS N l=0.18u w=0.3u
.ends JKFFSX2
*.SCALE meter
.GLOBAL GND VSS VDD

.subckt JKFFSX4 Q QN CK J K SN
M0 VDD SN s VDD P l=0.18u w=2.24u
M1 VDD net94 s VDD P l=0.18u w=2.24u
M2 hnet27 SN VSS VSS N l=0.18u w=0.98u
M3 s net94 hnet27 VSS N l=0.18u w=0.98u
M4 hnet23 SN VSS VSS N l=0.18u w=0.98u
M5 s net94 hnet23 VSS N l=0.18u w=0.98u
M6 VDD SN m VDD P l=0.18u w=0.62u
M7 VDD net98 m VDD P l=0.18u w=0.62u
M8 hnet31 SN VSS VSS N l=0.18u w=0.54u
M9 m net98 hnet31 VSS N l=0.18u w=0.54u
M10 VDD outn hnet33 VDD P l=0.18u w=0.56u
M11 hnet33 K net52 VDD P l=0.18u w=0.56u
M12 net52 outn VSS VSS N l=0.18u w=0.3u
M13 net52 K VSS VSS N l=0.18u w=0.3u
M14 net57 outn net60 VSS N l=0.18u w=0.3u
M15 net60 J VSS VSS N l=0.18u w=0.3u
M16 net98 cn net57 VSS N l=0.18u w=0.3u
M17 net57 net52 VSS VSS N l=0.18u w=0.3u
M18 net74 net52 net78 VDD P l=0.18u w=0.46u
M19 net78 outn VDD VDD P l=0.18u w=0.42u
M20 net98 c net74 VDD P l=0.18u w=0.46u
M21 net78 J VDD VDD P l=0.18u w=0.42u
M22 Q outn VSS VSS N l=0.18u w=2.4u
M23 VDD outn Q VDD P l=0.18u w=3.6u
M24 QN s VSS VSS N l=0.18u w=2.4u
M25 VDD s QN VDD P l=0.18u w=3.6u
M26 outn s VSS VSS N l=0.18u w=1.2u
M27 VDD s outn VDD P l=0.18u w=1.8u
M28 c cn VSS VSS N l=0.18u w=0.34u
M29 VDD cn c VDD P l=0.18u w=0.52u
M30 cn CK VSS VSS N l=0.18u w=0.58u
M31 VDD CK cn VDD P l=0.18u w=0.88u
M32 hnet49 cn net94 VDD P l=0.18u w=1.72u
M33 VDD m hnet49 VDD P l=0.18u w=1.72u
M34 hnet47 m VSS VSS N l=0.18u w=1.06u
M35 net94 c hnet47 VSS N l=0.18u w=1.06u
M36 hnet55 c net94 VDD P l=0.18u w=0.3u
M37 VDD s hnet55 VDD P l=0.18u w=0.3u
M38 hnet53 s VSS VSS N l=0.18u w=0.3u
M39 net94 cn hnet53 VSS N l=0.18u w=0.3u
M40 hnet61 cn net98 VDD P l=0.18u w=0.42u
M41 VDD m hnet61 VDD P l=0.18u w=0.42u
M42 hnet59 m VSS VSS N l=0.18u w=0.3u
M43 net98 c hnet59 VSS N l=0.18u w=0.3u
.ends JKFFSX4
*.SCALE meter
.GLOBAL GND VSS VDD

.subckt JKFFSXL Q QN CK J K SN
M0 VDD SN s VDD P l=0.18u w=0.42u
M1 VDD net94 s VDD P l=0.18u w=0.42u
M2 hnet26 SN VSS VSS N l=0.18u w=0.36u
M3 s net94 hnet26 VSS N l=0.18u w=0.36u
M4 VDD SN m VDD P l=0.18u w=0.42u
M5 VDD net98 m VDD P l=0.18u w=0.42u
M6 hnet30 SN VSS VSS N l=0.18u w=0.36u
M7 m net98 hnet30 VSS N l=0.18u w=0.36u
M8 VDD outn hnet32 VDD P l=0.18u w=0.56u
M9 hnet32 K net52 VDD P l=0.18u w=0.56u
M10 net52 outn VSS VSS N l=0.18u w=0.3u
M11 net52 K VSS VSS N l=0.18u w=0.3u
M12 net57 outn net60 VSS N l=0.18u w=0.44u
M13 net60 J VSS VSS N l=0.18u w=0.44u
M14 net98 cn net57 VSS N l=0.18u w=0.44u
M15 net57 net52 VSS VSS N l=0.18u w=0.36u
M16 net74 net52 net78 VDD P l=0.18u w=0.66u
M17 net78 outn VDD VDD P l=0.18u w=0.66u
M18 net98 c net74 VDD P l=0.18u w=0.66u
M19 net78 J VDD VDD P l=0.18u w=0.66u
M20 Q outn VSS VSS N l=0.18u w=0.42u
M21 VDD outn Q VDD P l=0.18u w=0.64u
M22 QN s VSS VSS N l=0.18u w=0.42u
M23 VDD s QN VDD P l=0.18u w=0.64u
M24 outn s VSS VSS N l=0.18u w=0.3u
M25 VDD s outn VDD P l=0.18u w=0.42u
M26 c cn VSS VSS N l=0.18u w=0.3u
M27 VDD cn c VDD P l=0.18u w=0.42u
M28 cn CK VSS VSS N l=0.18u w=0.3u
M29 VDD CK cn VDD P l=0.18u w=0.46u
M30 hnet48 cn net94 VDD P l=0.18u w=0.84u
M31 VDD m hnet48 VDD P l=0.18u w=0.84u
M32 hnet46 m VSS VSS N l=0.18u w=0.56u
M33 net94 c hnet46 VSS N l=0.18u w=0.56u
M34 hnet54 c net94 VDD P l=0.18u w=0.3u
M35 VDD s hnet54 VDD P l=0.18u w=0.3u
M36 hnet52 s VSS VSS N l=0.18u w=0.3u
M37 net94 cn hnet52 VSS N l=0.18u w=0.3u
M38 hnet60 cn net98 VDD P l=0.18u w=0.42u
M39 VDD m hnet60 VDD P l=0.18u w=0.42u
M40 hnet58 m VSS VSS N l=0.18u w=0.3u
M41 net98 c hnet58 VSS N l=0.18u w=0.3u
.ends JKFFSXL
*.SCALE meter
.GLOBAL GND VSS VDD

.subckt JKFFX1 Q QN CK J K
M0 VDD K hnet23 VDD P l=0.18u w=0.3u
M1 hnet23 s net46 VDD P l=0.18u w=0.3u
M2 VDD s net50 VDD P l=0.18u w=0.32u
M3 VDD J net50 VDD P l=0.18u w=0.32u
M4 hnet27 s VSS VSS N l=0.18u w=0.3u
M5 net50 J hnet27 VSS N l=0.18u w=0.3u
M6 net60 s VSS VSS N l=0.18u w=0.3u
M7 net62 net50 net60 VSS N l=0.18u w=0.3u
M8 net60 K VSS VSS N l=0.18u w=0.3u
M9 net91 cn net62 VSS N l=0.18u w=0.3u
M10 net46 net50 VDD VDD P l=0.18u w=0.3u
M11 net91 c net46 VDD P l=0.18u w=0.3u
M12 QN net83 VSS VSS N l=0.18u w=0.5u
M13 VDD net83 QN VDD P l=0.18u w=0.82u
M14 Q s VSS VSS N l=0.18u w=0.6u
M15 VDD s Q VDD P l=0.18u w=0.9u
M16 s net83 VSS VSS N l=0.18u w=0.42u
M17 VDD net83 s VDD P l=0.18u w=0.6u
M18 m net91 VSS VSS N l=0.18u w=0.3u
M19 VDD net91 m VDD P l=0.18u w=0.44u
M20 c cn VSS VSS N l=0.18u w=0.3u
M21 VDD cn c VDD P l=0.18u w=0.42u
M22 cn CK VSS VSS N l=0.18u w=0.46u
M23 VDD CK cn VDD P l=0.18u w=0.68u
M24 hnet43 cn net83 VDD P l=0.18u w=1.24u
M25 VDD m hnet43 VDD P l=0.18u w=1.24u
M26 hnet41 m VSS VSS N l=0.18u w=0.82u
M27 net83 c hnet41 VSS N l=0.18u w=0.82u
M28 hnet49 c net83 VDD P l=0.18u w=0.3u
M29 VDD s hnet49 VDD P l=0.18u w=0.3u
M30 hnet47 s VSS VSS N l=0.18u w=0.3u
M31 net83 cn hnet47 VSS N l=0.18u w=0.3u
M32 hnet55 cn net91 VDD P l=0.18u w=0.42u
M33 VDD m hnet55 VDD P l=0.18u w=0.42u
M34 hnet53 m VSS VSS N l=0.18u w=0.3u
M35 net91 c hnet53 VSS N l=0.18u w=0.3u
.ends JKFFX1
*.SCALE meter
.GLOBAL GND VSS VDD

.subckt JKFFX2 Q QN CK J K
M0 VDD K hnet23 VDD P l=0.18u w=0.46u
M1 hnet23 s net46 VDD P l=0.18u w=0.46u
M2 hnet31 cn net50 VDD P l=0.18u w=1.14u
M3 hnet29 cn net50 VDD P l=0.18u w=1.14u
M4 VDD m hnet31 VDD P l=0.18u w=1.14u
M5 VDD m hnet29 VDD P l=0.18u w=1.14u
M6 hnet25 m VSS VSS N l=0.18u w=0.76u
M7 hnet26 m VSS VSS N l=0.18u w=0.76u
M8 net50 c hnet25 VSS N l=0.18u w=0.76u
M9 net50 c hnet26 VSS N l=0.18u w=0.76u
M10 VDD s net54 VDD P l=0.18u w=0.32u
M11 VDD J net54 VDD P l=0.18u w=0.32u
M12 hnet35 s VSS VSS N l=0.18u w=0.3u
M13 net54 J hnet35 VSS N l=0.18u w=0.3u
M14 net64 s VSS VSS N l=0.18u w=0.32u
M15 net66 net54 net64 VSS N l=0.18u w=0.32u
M16 net64 K VSS VSS N l=0.18u w=0.32u
M17 net91 cn net66 VSS N l=0.18u w=0.32u
M18 net46 net54 VDD VDD P l=0.18u w=0.4u
M19 net91 c net46 VDD P l=0.18u w=0.46u
M20 QN net50 VSS VSS N l=0.18u w=1.2u
M21 VDD net50 QN VDD P l=0.18u w=1.8u
M22 Q s VSS VSS N l=0.18u w=1.2u
M23 VDD s Q VDD P l=0.18u w=1.8u
M24 s net50 VSS VSS N l=0.18u w=0.78u
M25 VDD net50 s VDD P l=0.18u w=1.16u
M26 m net91 VSS VSS N l=0.18u w=0.5u
M27 VDD net91 m VDD P l=0.18u w=0.76u
M28 c cn VSS VSS N l=0.18u w=0.4u
M29 VDD cn c VDD P l=0.18u w=0.6u
M30 cn CK VSS VSS N l=0.18u w=0.57u
M31 VDD CK cn VDD P l=0.18u w=1u
M32 hnet51 c net50 VDD P l=0.18u w=0.3u
M33 VDD s hnet51 VDD P l=0.18u w=0.3u
M34 hnet49 s VSS VSS N l=0.18u w=0.3u
M35 net50 cn hnet49 VSS N l=0.18u w=0.3u
M36 hnet57 cn net91 VDD P l=0.18u w=0.42u
M37 VDD m hnet57 VDD P l=0.18u w=0.42u
M38 hnet55 m VSS VSS N l=0.18u w=0.28u
M39 net91 c hnet55 VSS N l=0.18u w=0.28u
.ends JKFFX2
*.SCALE meter
.GLOBAL GND VSS VDD

.subckt JKFFX4 Q QN CK J K
M0 VDD K hnet23 VDD P l=0.18u w=0.86u
M1 hnet23 s net46 VDD P l=0.18u w=0.86u
M2 hnet27 cn net50 VDD P l=0.18u w=1.5u
M3 hnet29 cn net50 VDD P l=0.18u w=1.5u
M4 hnet26 cn net50 VDD P l=0.18u w=1.5u
M5 VDD m hnet27 VDD P l=0.18u w=1.5u
M6 VDD m hnet29 VDD P l=0.18u w=1.5u
M7 VDD m hnet26 VDD P l=0.18u w=1.5u
M8 hnet25 m VSS VSS N l=0.18u w=1u
M9 hnet28 m VSS VSS N l=0.18u w=1u
M10 hnet32 m VSS VSS N l=0.18u w=1u
M11 net50 c hnet25 VSS N l=0.18u w=1u
M12 net50 c hnet28 VSS N l=0.18u w=1u
M13 net50 c hnet32 VSS N l=0.18u w=1u
M14 VDD s net54 VDD P l=0.18u w=0.32u
M15 VDD J net54 VDD P l=0.18u w=0.32u
M16 hnet37 s VSS VSS N l=0.18u w=0.3u
M17 net54 J hnet37 VSS N l=0.18u w=0.3u
M18 net64 s VSS VSS N l=0.18u w=0.58u
M19 net61 net54 net64 VSS N l=0.18u w=0.58u
M20 net64 K VSS VSS N l=0.18u w=0.58u
M21 net91 cn net61 VSS N l=0.18u w=0.58u
M22 net46 net54 VDD VDD P l=0.18u w=0.74u
M23 net91 c net46 VDD P l=0.18u w=0.86u
M24 QN net50 VSS VSS N l=0.18u w=2.4u
M25 VDD net50 QN VDD P l=0.18u w=3.6u
M26 Q s VSS VSS N l=0.18u w=2.4u
M27 VDD s Q VDD P l=0.18u w=3.6u
M28 m net91 VSS VSS N l=0.18u w=0.92u
M29 VDD net91 m VDD P l=0.18u w=1.38u
M30 c cn VSS VSS N l=0.18u w=0.7u
M31 VDD cn c VDD P l=0.18u w=1u
M32 s net50 VSS VSS N l=0.18u w=1.36u
M33 VDD net50 s VDD P l=0.19u w=2.05u
M34 cn CK VSS VSS N l=0.19u w=1.2u
M35 VDD CK cn VDD P l=0.18u w=1.8u
M36 hnet53 c net50 VDD P l=0.18u w=0.3u
M37 VDD s hnet53 VDD P l=0.18u w=0.3u
M38 hnet51 s VSS VSS N l=0.18u w=0.3u
M39 net50 cn hnet51 VSS N l=0.18u w=0.3u
M40 hnet59 cn net91 VDD P l=0.18u w=0.42u
M41 VDD m hnet59 VDD P l=0.18u w=0.42u
M42 hnet57 m VSS VSS N l=0.18u w=0.3u
M43 net91 c hnet57 VSS N l=0.18u w=0.3u
.ends JKFFX4
*.SCALE meter
.GLOBAL GND VSS VDD

.subckt JKFFXL Q QN CK J K
M0 VDD K hnet23 VDD P l=0.18u w=0.66u
M1 hnet23 s net46 VDD P l=0.18u w=0.66u
M2 VDD s net50 VDD P l=0.18u w=0.42u
M3 VDD J net50 VDD P l=0.18u w=0.42u
M4 hnet27 s VSS VSS N l=0.18u w=0.36u
M5 net50 J hnet27 VSS N l=0.18u w=0.36u
M6 net60 s VSS VSS N l=0.18u w=0.46u
M7 net62 net50 net60 VSS N l=0.18u w=0.46u
M8 net60 K VSS VSS N l=0.18u w=0.46u
M9 net91 cn net62 VSS N l=0.18u w=0.46u
M10 net46 net50 VDD VDD P l=0.18u w=0.56u
M11 net91 c net46 VDD P l=0.18u w=0.66u
M12 QN net83 VSS VSS N l=0.18u w=0.42u
M13 VDD net83 QN VDD P l=0.18u w=0.64u
M14 Q s VSS VSS N l=0.18u w=0.42u
M15 VDD s Q VDD P l=0.18u w=0.64u
M16 s net83 VSS VSS N l=0.18u w=0.3u
M17 VDD net83 s VDD P l=0.18u w=0.42u
M18 m net91 VSS VSS N l=0.18u w=0.3u
M19 VDD net91 m VDD P l=0.18u w=0.42u
M20 c cn VSS VSS N l=0.18u w=0.3u
M21 VDD cn c VDD P l=0.18u w=0.42u
M22 cn CK VSS VSS N l=0.18u w=0.3u
M23 VDD CK cn VDD P l=0.18u w=0.42u
M24 hnet43 cn net83 VDD P l=0.18u w=0.84u
M25 VDD m hnet43 VDD P l=0.18u w=0.84u
M26 hnet41 m VSS VSS N l=0.18u w=0.56u
M27 net83 c hnet41 VSS N l=0.18u w=0.56u
M28 hnet49 c net83 VDD P l=0.18u w=0.3u
M29 VDD s hnet49 VDD P l=0.18u w=0.3u
M30 hnet47 s VSS VSS N l=0.18u w=0.3u
M31 net83 cn hnet47 VSS N l=0.18u w=0.3u
M32 hnet55 cn net91 VDD P l=0.18u w=0.42u
M33 VDD m hnet55 VDD P l=0.18u w=0.42u
M34 hnet53 m VSS VSS N l=0.18u w=0.3u
M35 net91 c hnet53 VSS N l=0.18u w=0.3u
.ends JKFFXL
*.SCALE meter
.GLOBAL GND VSS VDD

.subckt MX2X1 Y A B S0
M0 net27 net43 net39 VSS N l=0.18u w=0.48u
M1 net27 S0 net41 VSS N l=0.18u w=0.48u
M2 net27 S0 net39 VDD P l=0.18u w=0.72u
M3 net27 net43 net41 VDD P l=0.18u w=0.72u
M4 Y net27 VSS VSS N l=0.18u w=0.6u
M5 VDD net27 Y VDD P l=0.18u w=0.9u
M6 net39 A VSS VSS N l=0.18u w=0.48u
M7 VDD A net39 VDD P l=0.18u w=0.72u
M8 net41 B VSS VSS N l=0.18u w=0.48u
M9 VDD B net41 VDD P l=0.18u w=0.72u
M10 net43 S0 VSS VSS N l=0.18u w=0.3u
M11 VDD S0 net43 VDD P l=0.18u w=0.42u
.ends MX2X1
*.SCALE meter
.GLOBAL GND VSS VDD

.subckt MX2X2 Y A B S0
M0 net27 net43 net39 VSS N l=0.18u w=0.96u
M1 net27 S0 net41 VSS N l=0.18u w=0.96u
M2 net27 S0 net39 VDD P l=0.18u w=1.36u
M3 net27 net43 net41 VDD P l=0.18u w=1.36u
M4 Y net27 VSS VSS N l=0.18u w=1.2u
M5 VDD net27 Y VDD P l=0.18u w=1.77u
M6 net39 A VSS VSS N l=0.18u w=0.96u
M7 VDD A net39 VDD P l=0.18u w=1.36u
M8 net41 B VSS VSS N l=0.18u w=0.86u
M9 VDD B net41 VDD P l=0.18u w=1.36u
M10 net43 S0 VSS VSS N l=0.18u w=0.38u
M11 VDD S0 net43 VDD P l=0.18u w=0.56u
.ends MX2X2
*.SCALE meter
.GLOBAL GND VSS VDD

.subckt MX2X4 Y A B S0
M0 Y net31 VSS VSS N l=0.19u w=2.4u
M1 VDD net31 Y VDD P l=0.18u w=3.52u
M2 net27 A VSS VSS N l=0.19u w=1.2u
M3 VDD A net27 VDD P l=0.18u w=1.76u
M4 net31 net43 net27 VSS N l=0.18u w=1.07u
M5 net31 S0 net41 VSS N l=0.18u w=1.07u
M6 net31 S0 net27 VDD P l=0.18u w=1.76u
M7 net31 net43 net41 VDD P l=0.18u w=1.54u
M8 net41 B VSS VSS N l=0.18u w=1.07u
M9 VDD B net41 VDD P l=0.18u w=1.54u
M10 net43 S0 VSS VSS N l=0.18u w=0.48u
M11 VDD S0 net43 VDD P l=0.18u w=0.72u
.ends MX2X4
*.SCALE meter
.GLOBAL GND VSS VDD

.subckt MX2XL Y A B S0
M0 net27 net43 net39 VSS N l=0.18u w=0.56u
M1 net27 S0 net41 VSS N l=0.18u w=0.56u
M2 net27 S0 net39 VDD P l=0.18u w=0.84u
M3 net27 net43 net41 VDD P l=0.18u w=0.84u
M4 Y net27 VSS VSS N l=0.18u w=0.42u
M5 VDD net27 Y VDD P l=0.18u w=0.64u
M6 net39 A VSS VSS N l=0.18u w=0.3u
M7 VDD A net39 VDD P l=0.18u w=0.42u
M8 net41 B VSS VSS N l=0.18u w=0.3u
M9 VDD B net41 VDD P l=0.18u w=0.42u
M10 net43 S0 VSS VSS N l=0.18u w=0.3u
M11 VDD S0 net43 VDD P l=0.18u w=0.42u
.ends MX2XL
*.SCALE meter
.GLOBAL GND VSS VDD

.subckt MX4X1 Y A B C D S0 S1
M0 net59 net101 net93 VSS N l=0.18u w=0.72u
M1 net59 S0 net95 VSS N l=0.18u w=0.72u
M2 net65 net101 net97 VSS N l=0.18u w=0.72u
M3 net65 S0 net99 VSS N l=0.18u w=0.72u
M4 net71 net105 net59 VSS N l=0.18u w=0.72u
M5 net71 S1 net65 VSS N l=0.18u w=0.72u
M6 net59 S0 net93 VDD P l=0.18u w=1.08u
M7 net59 net101 net95 VDD P l=0.18u w=1.08u
M8 net65 S0 net97 VDD P l=0.18u w=1.08u
M9 net65 net101 net99 VDD P l=0.18u w=1.08u
M10 net71 S1 net59 VDD P l=0.18u w=1.08u
M11 net71 net105 net65 VDD P l=0.18u w=1.08u
M12 net93 A VSS VSS N l=0.18u w=0.72u
M13 VDD A net93 VDD P l=0.18u w=1.08u
M14 net95 B VSS VSS N l=0.18u w=0.72u
M15 VDD B net95 VDD P l=0.18u w=1.08u
M16 net97 C VSS VSS N l=0.18u w=0.72u
M17 VDD C net97 VDD P l=0.18u w=1.08u
M18 net99 D VSS VSS N l=0.18u w=0.72u
M19 VDD D net99 VDD P l=0.18u w=1.08u
M20 net101 S0 VSS VSS N l=0.18u w=0.58u
M21 VDD S0 net101 VDD P l=0.18u w=0.88u
M22 Y net71 VSS VSS N l=0.18u w=0.6u
M23 VDD net71 Y VDD P l=0.18u w=0.9u
M24 net105 S1 VSS VSS N l=0.18u w=0.3u
M25 VDD S1 net105 VDD P l=0.18u w=0.42u
.ends MX4X1
*.SCALE meter
.GLOBAL GND VSS VDD

.subckt MX4X2 Y A B C D S0 S1
M0 net59 net93 net95 VSS N l=0.18u w=1.2u
M1 net59 S0 net97 VSS N l=0.19u w=1.18u
M2 net65 net93 net99 VSS N l=0.18u w=1.2u
M3 net65 S0 net101 VSS N l=0.18u w=1.16u
M4 net71 net105 net59 VSS N l=0.18u w=1.2u
M5 net71 S1 net65 VSS N l=0.18u w=1.2u
M6 net59 S0 net95 VDD P l=0.18u w=1.74u
M7 net59 net93 net97 VDD P l=0.18u w=1.77u
M8 net65 S0 net99 VDD P l=0.18u w=1.74u
M9 net65 net93 net101 VDD P l=0.18u w=1.77u
M10 net71 S1 net59 VDD P l=0.18u w=1.76u
M11 net71 net105 net65 VDD P l=0.18u w=1.77u
M12 net93 S0 VSS VSS N l=0.19u w=0.98u
M13 VDD S0 net93 VDD P l=0.18u w=1.44u
M14 net95 A VSS VSS N l=0.18u w=1.2u
M15 VDD A net95 VDD P l=0.18u w=1.77u
M16 net97 B VSS VSS N l=0.18u w=1.2u
M17 VDD B net97 VDD P l=0.18u w=1.77u
M18 net99 C VSS VSS N l=0.18u w=1.2u
M19 VDD C net99 VDD P l=0.18u w=1.77u
M20 net101 D VSS VSS N l=0.18u w=1.2u
M21 VDD D net101 VDD P l=0.18u w=1.77u
M22 Y net71 VSS VSS N l=0.18u w=1.2u
M23 VDD net71 Y VDD P l=0.18u w=1.77u
M24 net105 S1 VSS VSS N l=0.18u w=0.48u
M25 VDD S1 net105 VDD P l=0.18u w=0.72u
.ends MX4X2
*.SCALE meter
.GLOBAL GND VSS VDD

.subckt MX4X4 Y A B C D S0 S1
M0 net59 net93 net97 VSS N l=0.18u w=1.2u
M1 net59 S0 net99 VSS N l=0.19u w=1.18u
M2 net65 net93 net101 VSS N l=0.18u w=1.2u
M3 net65 S0 net103 VSS N l=0.18u w=1.16u
M4 net71 net105 net59 VSS N l=0.18u w=1.2u
M5 net71 S1 net65 VSS N l=0.18u w=1.2u
M6 net59 S0 net97 VDD P l=0.18u w=1.74u
M7 net59 net93 net99 VDD P l=0.18u w=1.77u
M8 net65 S0 net101 VDD P l=0.18u w=1.74u
M9 net65 net93 net103 VDD P l=0.18u w=1.77u
M10 net71 S1 net59 VDD P l=0.18u w=1.76u
M11 net71 net105 net65 VDD P l=0.18u w=1.77u
M12 net93 S0 VSS VSS N l=0.19u w=0.98u
M13 VDD S0 net93 VDD P l=0.18u w=1.44u
M14 Y net71 VSS VSS N l=0.19u w=2.4u
M15 VDD net71 Y VDD P l=0.18u w=3.6u
M16 net97 A VSS VSS N l=0.18u w=1.2u
M17 VDD A net97 VDD P l=0.18u w=1.77u
M18 net99 B VSS VSS N l=0.18u w=1.2u
M19 VDD B net99 VDD P l=0.18u w=1.77u
M20 net101 C VSS VSS N l=0.18u w=1.2u
M21 VDD C net101 VDD P l=0.18u w=1.77u
M22 net103 D VSS VSS N l=0.18u w=1.2u
M23 VDD D net103 VDD P l=0.18u w=1.77u
M24 net105 S1 VSS VSS N l=0.18u w=0.48u
M25 VDD S1 net105 VDD P l=0.18u w=0.72u
.ends MX4X4
*.SCALE meter
.GLOBAL GND VSS VDD

.subckt MX4XL Y A B C D S0 S1
M0 net59 net101 net93 VSS N l=0.18u w=0.56u
M1 net59 S0 net95 VSS N l=0.18u w=0.56u
M2 net65 net101 net97 VSS N l=0.18u w=0.56u
M3 net65 S0 net99 VSS N l=0.18u w=0.56u
M4 net71 net105 net59 VSS N l=0.18u w=0.56u
M5 net71 S1 net65 VSS N l=0.18u w=0.56u
M6 net59 S0 net93 VDD P l=0.18u w=0.84u
M7 net59 net101 net95 VDD P l=0.18u w=0.84u
M8 net65 S0 net97 VDD P l=0.18u w=0.84u
M9 net65 net101 net99 VDD P l=0.18u w=0.84u
M10 net71 S1 net59 VDD P l=0.18u w=0.84u
M11 net71 net105 net65 VDD P l=0.18u w=0.84u
M12 net93 A VSS VSS N l=0.18u w=0.3u
M13 VDD A net93 VDD P l=0.18u w=0.42u
M14 net95 B VSS VSS N l=0.18u w=0.3u
M15 VDD B net95 VDD P l=0.18u w=0.42u
M16 net97 C VSS VSS N l=0.18u w=0.3u
M17 VDD C net97 VDD P l=0.18u w=0.42u
M18 net99 D VSS VSS N l=0.18u w=0.3u
M19 VDD D net99 VDD P l=0.18u w=0.42u
M20 net101 S0 VSS VSS N l=0.18u w=0.3u
M21 VDD S0 net101 VDD P l=0.18u w=0.42u
M22 Y net71 VSS VSS N l=0.18u w=0.42u
M23 VDD net71 Y VDD P l=0.18u w=0.64u
M24 net105 S1 VSS VSS N l=0.18u w=0.3u
M25 VDD S1 net105 VDD P l=0.18u w=0.42u
.ends MX4XL
*.SCALE meter
.GLOBAL GND VSS VDD

.subckt MXI2X1 Y A B S0
M0 Y net40 net36 VSS N l=0.18u w=0.66u
M1 Y S0 net38 VSS N l=0.18u w=0.66u
M2 Y S0 net36 VDD P l=0.18u w=1u
M3 Y net40 net38 VDD P l=0.18u w=1u
M4 net36 A VSS VSS N l=0.18u w=0.66u
M5 VDD A net36 VDD P l=0.18u w=1u
M6 net38 B VSS VSS N l=0.18u w=0.66u
M7 VDD B net38 VDD P l=0.18u w=1u
M8 net40 S0 VSS VSS N l=0.18u w=0.3u
M9 VDD S0 net40 VDD P l=0.18u w=0.46u
.ends MXI2X1
*.SCALE meter
.GLOBAL GND VSS VDD

.subckt MXI2X2 Y A B S0
M0 net24 A VSS VSS N l=0.19u w=1.21u
M1 VDD A net24 VDD P l=0.18u w=1.77u
M2 net26 B VSS VSS N l=0.19u w=0.97u
M3 VDD B net26 VDD P l=0.18u w=1.73u
M4 Y net40 net24 VSS N l=0.18u w=1.08u
M5 Y S0 net26 VSS N l=0.18u w=1.08u
M6 Y S0 net24 VDD P l=0.18u w=1.73u
M7 Y net40 net26 VDD P l=0.18u w=1.73u
M8 net40 S0 VSS VSS N l=0.18u w=0.48u
M9 VDD S0 net40 VDD P l=0.18u w=0.72u
.ends MXI2X2
*.SCALE meter
.GLOBAL GND VSS VDD

.subckt MXI2X4 Y A B S0
M0 Y net40 net36 VSS N l=0.19u w=2.38u
M1 Y S0 net38 VSS N l=0.19u w=2.4u
M2 Y S0 net36 VDD P l=0.18u w=3.6u
M3 Y net40 net38 VDD P l=0.18u w=3.6u
M4 net36 A VSS VSS N l=0.19u w=2.4u
M5 VDD A net36 VDD P l=0.18u w=3.6u
M6 net38 B VSS VSS N l=0.19u w=2.4u
M7 VDD B net38 VDD P l=0.18u w=3.6u
M8 net40 S0 VSS VSS N l=0.19u w=0.97u
M9 VDD S0 net40 VDD P l=0.18u w=1.45u
.ends MXI2X4
*.SCALE meter
.GLOBAL GND VSS VDD

.subckt MXI2XL Y A B S0
M0 Y net40 net36 VSS N l=0.18u w=0.56u
M1 Y S0 net38 VSS N l=0.18u w=0.56u
M2 Y S0 net36 VDD P l=0.18u w=0.84u
M3 Y net40 net38 VDD P l=0.18u w=0.84u
M4 net36 A VSS VSS N l=0.18u w=0.42u
M5 VDD A net36 VDD P l=0.18u w=0.64u
M6 net38 B VSS VSS N l=0.18u w=0.3u
M7 VDD B net38 VDD P l=0.18u w=0.42u
M8 net40 S0 VSS VSS N l=0.18u w=0.3u
M9 VDD S0 net40 VDD P l=0.18u w=0.42u
.ends MXI2XL
*.SCALE meter
.GLOBAL GND VSS VDD

.subckt MXI4X1 Y A B C D S0 S1
M0 net61 net107 net95 VSS N l=0.18u w=0.38u
M1 net61 S0 net97 VSS N l=0.18u w=0.38u
M2 net67 net107 net99 VSS N l=0.18u w=0.38u
M3 net67 S0 net101 VSS N l=0.18u w=0.38u
M4 net73 net111 net103 VSS N l=0.18u w=0.48u
M5 net73 S1 net105 VSS N l=0.18u w=0.48u
M6 net61 S0 net95 VDD P l=0.18u w=0.56u
M7 net61 net107 net97 VDD P l=0.18u w=0.56u
M8 net67 S0 net99 VDD P l=0.18u w=0.56u
M9 net67 net107 net101 VDD P l=0.18u w=0.56u
M10 net73 S1 net103 VDD P l=0.18u w=0.72u
M11 net73 net111 net105 VDD P l=0.18u w=0.72u
M12 net95 A VSS VSS N l=0.18u w=0.38u
M13 VDD A net95 VDD P l=0.18u w=0.56u
M14 net97 B VSS VSS N l=0.18u w=0.38u
M15 VDD B net97 VDD P l=0.18u w=0.56u
M16 net99 C VSS VSS N l=0.18u w=0.38u
M17 VDD C net99 VDD P l=0.18u w=0.56u
M18 net101 D VSS VSS N l=0.18u w=0.38u
M19 VDD D net101 VDD P l=0.18u w=0.56u
M20 net103 net61 VSS VSS N l=0.18u w=0.48u
M21 VDD net61 net103 VDD P l=0.18u w=0.72u
M22 net105 net67 VSS VSS N l=0.18u w=0.48u
M23 VDD net67 net105 VDD P l=0.18u w=0.72u
M24 net107 S0 VSS VSS N l=0.18u w=0.3u
M25 VDD S0 net107 VDD P l=0.18u w=0.44u
M26 Y net73 VSS VSS N l=0.18u w=0.6u
M27 VDD net73 Y VDD P l=0.18u w=0.9u
M28 net111 S1 VSS VSS N l=0.18u w=0.3u
M29 VDD S1 net111 VDD P l=0.18u w=0.42u
.ends MXI4X1
*.SCALE meter
.GLOBAL GND VSS VDD

.subckt MXI4X2 Y A B C D S0 S1
M0 net61 net107 net95 VSS N l=0.18u w=0.76u
M1 net61 S0 net97 VSS N l=0.18u w=0.76u
M2 net67 net107 net99 VSS N l=0.18u w=0.76u
M3 net67 S0 net101 VSS N l=0.18u w=0.76u
M4 net73 net111 net103 VSS N l=0.18u w=0.96u
M5 net73 S1 net105 VSS N l=0.18u w=0.96u
M6 net61 S0 net95 VDD P l=0.18u w=1.14u
M7 net61 net107 net97 VDD P l=0.18u w=1.14u
M8 net67 S0 net99 VDD P l=0.18u w=1.14u
M9 net67 net107 net101 VDD P l=0.18u w=1.14u
M10 net73 S1 net103 VDD P l=0.18u w=1.44u
M11 net73 net111 net105 VDD P l=0.18u w=1.44u
M12 net95 A VSS VSS N l=0.18u w=0.76u
M13 VDD A net95 VDD P l=0.18u w=1.14u
M14 net97 B VSS VSS N l=0.18u w=0.76u
M15 VDD B net97 VDD P l=0.18u w=1.14u
M16 net99 C VSS VSS N l=0.18u w=0.76u
M17 VDD C net99 VDD P l=0.18u w=1.14u
M18 net101 D VSS VSS N l=0.18u w=0.7u
M19 VDD D net101 VDD P l=0.18u w=1.14u
M20 net103 net61 VSS VSS N l=0.18u w=0.96u
M21 VDD net61 net103 VDD P l=0.18u w=1.44u
M22 net105 net67 VSS VSS N l=0.18u w=0.96u
M23 VDD net67 net105 VDD P l=0.18u w=1.44u
M24 net107 S0 VSS VSS N l=0.18u w=0.6u
M25 VDD S0 net107 VDD P l=0.18u w=0.9u
M26 Y net73 VSS VSS N l=0.18u w=1.2u
M27 VDD net73 Y VDD P l=0.18u w=1.72u
M28 net111 S1 VSS VSS N l=0.18u w=0.38u
M29 VDD S1 net111 VDD P l=0.18u w=0.56u
.ends MXI4X2
*.SCALE meter
.GLOBAL GND VSS VDD

.subckt MXI4X4 Y A B C D S0 S1
M0 net59 A VSS VSS N l=0.19u w=0.97u
M1 VDD A net59 VDD P l=0.18u w=1.44u
M2 net61 B VSS VSS N l=0.19u w=0.97u
M3 VDD B net61 VDD P l=0.18u w=1.4u
M4 net63 C VSS VSS N l=0.19u w=0.97u
M5 VDD C net63 VDD P l=0.18u w=1.44u
M6 net65 D VSS VSS N l=0.19u w=0.97u
M7 VDD D net65 VDD P l=0.18u w=1.39u
M8 net69 net107 net59 VSS N l=0.19u w=0.97u
M9 net69 S0 net61 VSS N l=0.19u w=0.97u
M10 net75 net107 net63 VSS N l=0.19u w=0.97u
M11 net75 S0 net65 VSS N l=0.19u w=0.97u
M12 net81 net111 net103 VSS N l=0.19u w=1.06u
M13 net81 S1 net105 VSS N l=0.18u w=1.2u
M14 net69 S0 net59 VDD P l=0.18u w=1.44u
M15 net69 net107 net61 VDD P l=0.18u w=1.4u
M16 net75 S0 net63 VDD P l=0.18u w=1.39u
M17 net75 net107 net65 VDD P l=0.18u w=1.39u
M18 net81 S1 net103 VDD P l=0.18u w=1.7u
M19 net81 net111 net105 VDD P l=0.18u w=1.7u
M20 net103 net69 VSS VSS N l=0.18u w=1.2u
M21 VDD net69 net103 VDD P l=0.18u w=1.77u
M22 net105 net75 VSS VSS N l=0.18u w=1.2u
M23 VDD net75 net105 VDD P l=0.18u w=1.7u
M24 net107 S0 VSS VSS N l=0.18u w=0.76u
M25 VDD S0 net107 VDD P l=0.18u w=1.14u
M26 Y net81 VSS VSS N l=0.18u w=2.4u
M27 VDD net81 Y VDD P l=0.18u w=3.54u
M28 net111 S1 VSS VSS N l=0.18u w=0.48u
M29 VDD S1 net111 VDD P l=0.18u w=0.72u
.ends MXI4X4
*.SCALE meter
.GLOBAL GND VSS VDD

.subckt MXI4XL Y A B C D S0 S1
M0 net61 net107 net95 VSS N l=0.18u w=0.56u
M1 net61 S0 net97 VSS N l=0.18u w=0.56u
M2 net67 net107 net99 VSS N l=0.18u w=0.56u
M3 net67 S0 net101 VSS N l=0.18u w=0.56u
M4 net73 net111 net103 VSS N l=0.18u w=0.56u
M5 net73 S1 net105 VSS N l=0.18u w=0.56u
M6 net61 S0 net95 VDD P l=0.18u w=0.84u
M7 net61 net107 net97 VDD P l=0.18u w=0.84u
M8 net67 S0 net99 VDD P l=0.18u w=0.84u
M9 net67 net107 net101 VDD P l=0.18u w=0.84u
M10 net73 S1 net103 VDD P l=0.18u w=0.84u
M11 net73 net111 net105 VDD P l=0.18u w=0.84u
M12 net95 A VSS VSS N l=0.18u w=0.3u
M13 VDD A net95 VDD P l=0.18u w=0.42u
M14 net97 B VSS VSS N l=0.18u w=0.3u
M15 VDD B net97 VDD P l=0.18u w=0.42u
M16 net99 C VSS VSS N l=0.18u w=0.3u
M17 VDD C net99 VDD P l=0.18u w=0.42u
M18 net101 D VSS VSS N l=0.18u w=0.3u
M19 VDD D net101 VDD P l=0.18u w=0.42u
M20 net103 net61 VSS VSS N l=0.18u w=0.3u
M21 VDD net61 net103 VDD P l=0.18u w=0.42u
M22 net105 net67 VSS VSS N l=0.18u w=0.3u
M23 VDD net67 net105 VDD P l=0.18u w=0.42u
M24 net107 S0 VSS VSS N l=0.18u w=0.3u
M25 VDD S0 net107 VDD P l=0.18u w=0.42u
M26 Y net73 VSS VSS N l=0.18u w=0.42u
M27 VDD net73 Y VDD P l=0.18u w=0.64u
M28 net111 S1 VSS VSS N l=0.18u w=0.3u
M29 VDD S1 net111 VDD P l=0.18u w=0.42u
.ends MXI4XL
*.SCALE meter
.GLOBAL GND VSS VDD

.subckt NAND2BX1 Y AN B
M0 net9 AN VSS VSS N l=0.18u w=0.3u
M1 VDD AN net9 VDD P l=0.18u w=0.42u
M2 VDD B Y VDD P l=0.18u w=0.9u
M3 VDD net9 Y VDD P l=0.18u w=0.9u
M4 hnet14 B VSS VSS N l=0.18u w=0.8u
M5 Y net9 hnet14 VSS N l=0.18u w=0.8u
.ends NAND2BX1
*.SCALE meter
.GLOBAL GND VDD VSS

.subckt NAND2BX2 Y AN B
M0 Y B VDD VDD P l=0.18u w=1.81u
M1 Y net22 VDD VDD P l=0.18u w=1.84u
M2 hnet13 B VSS VSS N l=0.18u w=0.8u
M3 Y net22 hnet13 VSS N l=0.18u w=0.8u
M4 hnet9 B VSS VSS N l=0.18u w=0.8u
M5 Y net22 hnet9 VSS N l=0.18u w=0.8u
M6 net22 AN VSS VSS N l=0.18u w=0.54u
M7 VDD AN net22 VDD P l=0.18u w=0.8u
.ends NAND2BX2
*.SCALE meter
.GLOBAL GND VDD VSS

.subckt NAND2BX4 Y AN B
M0 hnet10 B VSS VSS N l=0.18u w=1.24u
M1 Y net28 hnet10 VSS N l=0.18u w=1.24u
M2 hnet15 B VSS VSS N l=0.18u w=0.7u
M3 Y net28 hnet15 VSS N l=0.18u w=0.7u
M4 hnet20 B VSS VSS N l=0.18u w=1.24u
M5 Y net28 hnet20 VSS N l=0.18u w=1.24u
M6 Y B VDD VDD P l=0.18u w=3.54u
M7 Y net28 VDD VDD P l=0.18u w=3.54u
M8 net28 AN VSS VSS N l=0.18u w=1.08u
M9 VDD AN net28 VDD P l=0.18u w=1.63u
.ends NAND2BX4
*.SCALE meter
.GLOBAL GND VSS VDD

.subckt NAND2BXL Y AN B
M0 net9 AN VSS VSS N l=0.18u w=0.3u
M1 VDD AN net9 VDD P l=0.18u w=0.42u
M2 VDD B Y VDD P l=0.18u w=0.64u
M3 VDD net9 Y VDD P l=0.18u w=0.64u
M4 hnet14 B VSS VSS N l=0.18u w=0.56u
M5 Y net9 hnet14 VSS N l=0.18u w=0.56u
.ends NAND2BXL
*.SCALE meter
.GLOBAL GND VSS VDD

.subckt NAND2X1 Y A B
M0 VDD B Y VDD P l=0.18u w=0.9u
M1 VDD A Y VDD P l=0.18u w=0.9u
M2 hnet10 B VSS VSS N l=0.18u w=0.78u
M3 Y A hnet10 VSS N l=0.18u w=0.78u
.ends NAND2X1
*.SCALE meter
.GLOBAL GND VDD VSS

.subckt NAND2X2 Y A B
M0 Y B VDD VDD P l=0.18u w=1.86u
M1 Y A VDD VDD P l=0.18u w=1.86u
M2 hnet9 B VSS VSS N l=0.18u w=0.75u
M3 Y A hnet9 VSS N l=0.18u w=0.75u
M4 hnet14 B VSS VSS N l=0.18u w=0.85u
M5 Y A hnet14 VSS N l=0.18u w=0.85u
.ends NAND2X2
*.SCALE meter
.GLOBAL GND VDD VSS

.subckt NAND2X4 Y A B
M0 hnet9 B VSS VSS N l=0.18u w=1.24u
M1 Y A hnet9 VSS N l=0.18u w=1.24u
M2 hnet14 B VSS VSS N l=0.18u w=0.68u
M3 Y A hnet14 VSS N l=0.18u w=0.68u
M4 hnet19 B VSS VSS N l=0.18u w=1.26u
M5 Y A hnet19 VSS N l=0.18u w=1.26u
M6 Y B VDD VDD P l=0.18u w=3.54u
M7 Y A VDD VDD P l=0.18u w=3.54u
.ends NAND2X4
*.SCALE meter
.GLOBAL GND VSS VDD

.subckt NAND2XL Y A B
M0 VDD B Y VDD P l=0.18u w=0.64u
M1 VDD A Y VDD P l=0.18u w=0.64u
M2 hnet10 B VSS VSS N l=0.18u w=0.56u
M3 Y A hnet10 VSS N l=0.18u w=0.56u
.ends NAND2XL
*.SCALE meter
.GLOBAL GND VSS VDD

.subckt NAND3BX1 Y AN B C
M0 net11 AN VSS VSS N l=0.18u w=0.3u
M1 VDD AN net11 VDD P l=0.18u w=0.44u
M2 VDD C Y VDD P l=0.18u w=1u
M3 VDD B Y VDD P l=0.18u w=1u
M4 VDD net11 Y VDD P l=0.18u w=1u
M5 hnet17 C VSS VSS N l=0.18u w=0.96u
M6 hnet12 B hnet17 VSS N l=0.18u w=0.96u
M7 Y net11 hnet12 VSS N l=0.18u w=0.96u
.ends NAND3BX1
*.SCALE meter
.GLOBAL GND VSS VDD

.subckt NAND3BX2 Y AN B C
M0 net11 AN VSS VSS N l=0.18u w=0.6u
M1 VDD AN net11 VDD P l=0.18u w=0.9u
M2 VDD C Y VDD P l=0.18u w=1.82u
M3 VDD B Y VDD P l=0.18u w=1.82u
M4 VDD net11 Y VDD P l=0.18u w=1.82u
M5 hnet18 C VSS VSS N l=0.18u w=0.96u
M6 hnet12 B hnet18 VSS N l=0.18u w=0.96u
M7 Y net11 hnet12 VSS N l=0.18u w=0.96u
M8 hnet19 C VSS VSS N l=0.18u w=0.96u
M9 hnet14 B hnet19 VSS N l=0.18u w=0.96u
M10 Y net11 hnet14 VSS N l=0.18u w=0.96u
.ends NAND3BX2
*.SCALE meter
.GLOBAL GND VDD VSS

.subckt NAND3BX4 Y AN B C
M0 Y C VDD VDD P l=0.18u w=2.92u
M1 Y B VDD VDD P l=0.18u w=2.93u
M2 Y net38 VDD VDD P l=0.18u w=2.93u
M3 hnet14 C VSS VSS N l=0.18u w=1.02u
M4 hnet9 B hnet14 VSS N l=0.18u w=1.02u
M5 Y net38 hnet9 VSS N l=0.18u w=1.02u
M6 hnet21 C VSS VSS N l=0.18u w=1.02u
M7 hnet16 B hnet21 VSS N l=0.18u w=1.02u
M8 Y net38 hnet16 VSS N l=0.18u w=1.02u
M9 hnet28 C VSS VSS N l=0.18u w=0.94u
M10 hnet23 B hnet28 VSS N l=0.18u w=0.94u
M11 Y net38 hnet23 VSS N l=0.18u w=0.94u
M12 net38 AN VSS VSS N l=0.18u w=1.12u
M13 VDD AN net38 VDD P l=0.18u w=1.68u
.ends NAND3BX4
*.SCALE meter
.GLOBAL GND VSS VDD

.subckt NAND3BXL Y AN B C
M0 net11 AN VSS VSS N l=0.18u w=0.3u
M1 VDD AN net11 VDD P l=0.18u w=0.42u
M2 VDD C Y VDD P l=0.18u w=0.64u
M3 VDD B Y VDD P l=0.18u w=0.64u
M4 VDD net11 Y VDD P l=0.18u w=0.64u
M5 hnet17 C VSS VSS N l=0.18u w=0.66u
M6 hnet12 B hnet17 VSS N l=0.18u w=0.66u
M7 Y net11 hnet12 VSS N l=0.18u w=0.66u
.ends NAND3BXL
*.SCALE meter
.GLOBAL GND VSS VDD

.subckt NAND3X1 Y A B C
M0 VDD C Y VDD P l=0.18u w=1.01u
M1 VDD B Y VDD P l=0.18u w=1.01u
M2 VDD A Y VDD P l=0.18u w=1.01u
M3 hnet14 C VSS VSS N l=0.18u w=0.96u
M4 hnet7 B hnet14 VSS N l=0.18u w=0.96u
M5 Y A hnet7 VSS N l=0.18u w=0.96u
.ends NAND3X1
*.SCALE meter
.GLOBAL GND VSS VDD

.subckt NAND3X2 Y A B C
M0 VDD C Y VDD P l=0.18u w=1.82u
M1 VDD B Y VDD P l=0.18u w=1.82u
M2 VDD A Y VDD P l=0.18u w=1.82u
M3 hnet15 C VSS VSS N l=0.18u w=0.96u
M4 hnet7 B hnet15 VSS N l=0.18u w=0.96u
M5 Y A hnet7 VSS N l=0.18u w=0.96u
M6 hnet16 C VSS VSS N l=0.18u w=0.96u
M7 hnet10 B hnet16 VSS N l=0.18u w=0.96u
M8 Y A hnet10 VSS N l=0.18u w=0.96u
.ends NAND3X2
*.SCALE meter
.GLOBAL GND VSS VDD

.subckt NAND3X4 Y A B C
M0 VDD C Y VDD P l=0.18u w=2.86u
M1 VDD B Y VDD P l=0.18u w=2.86u
M2 VDD A Y VDD P l=0.18u w=2.86u
M3 hnet16 C VSS VSS N l=0.18u w=1u
M4 hnet7 B hnet16 VSS N l=0.18u w=1u
M5 Y A hnet7 VSS N l=0.18u w=1u
M6 hnet18 C VSS VSS N l=0.18u w=1u
M7 hnet11 B hnet18 VSS N l=0.18u w=1u
M8 Y A hnet11 VSS N l=0.18u w=1u
M9 hnet12 C VSS VSS N l=0.18u w=1u
M10 hnet8 B hnet12 VSS N l=0.18u w=1u
M11 Y A hnet8 VSS N l=0.18u w=1u
.ends NAND3X4
*.SCALE meter
.GLOBAL GND VSS VDD

.subckt NAND3XL Y A B C
M0 VDD C Y VDD P l=0.18u w=0.64u
M1 VDD B Y VDD P l=0.18u w=0.64u
M2 VDD A Y VDD P l=0.18u w=0.64u
M3 hnet14 C VSS VSS N l=0.18u w=0.66u
M4 hnet7 B hnet14 VSS N l=0.18u w=0.66u
M5 Y A hnet7 VSS N l=0.18u w=0.66u
.ends NAND3XL
*.SCALE meter
.GLOBAL GND VSS VDD

.subckt NAND4BBX1 Y AN BN C D
M0 net15 BN VSS VSS N l=0.18u w=0.3u
M1 VDD BN net15 VDD P l=0.18u w=0.44u
M2 net17 AN VSS VSS N l=0.18u w=0.3u
M3 VDD AN net17 VDD P l=0.18u w=0.44u
M4 VDD D Y VDD P l=0.18u w=0.96u
M5 VDD C Y VDD P l=0.18u w=0.96u
M6 VDD net15 Y VDD P l=0.18u w=0.96u
M7 VDD net17 Y VDD P l=0.18u w=0.96u
M8 hnet20 D VSS VSS N l=0.18u w=1.04u
M9 hnet18 C hnet20 VSS N l=0.18u w=1.04u
M10 hnet19 net15 hnet18 VSS N l=0.18u w=1.04u
M11 Y net17 hnet19 VSS N l=0.18u w=1.04u
.ends NAND4BBX1
*.SCALE meter
.GLOBAL GND VSS VDD

.subckt NAND4BBX2 Y AN BN C D
M0 net15 BN VSS VSS N l=0.18u w=0.62u
M1 VDD BN net15 VDD P l=0.18u w=0.92u
M2 net17 AN VSS VSS N l=0.18u w=0.62u
M3 VDD AN net17 VDD P l=0.18u w=0.92u
M4 VDD D Y VDD P l=0.18u w=1.82u
M5 VDD C Y VDD P l=0.18u w=1.82u
M6 VDD net15 Y VDD P l=0.18u w=1.82u
M7 VDD net17 Y VDD P l=0.18u w=1.82u
M8 hnet20 D VSS VSS N l=0.18u w=1.04u
M9 hnet19 C hnet20 VSS N l=0.18u w=1.04u
M10 hnet18 net15 hnet19 VSS N l=0.18u w=1.04u
M11 Y net17 hnet18 VSS N l=0.18u w=1.04u
M12 hnet23 D VSS VSS N l=0.18u w=1.04u
M13 hnet27 C hnet23 VSS N l=0.18u w=1.04u
M14 hnet22 net15 hnet27 VSS N l=0.18u w=1.04u
M15 Y net17 hnet22 VSS N l=0.18u w=1.04u
.ends NAND4BBX2
*.SCALE meter
.GLOBAL GND VSS VDD

.subckt NAND4BBX4 Y AN BN C D
M0 net15 BN VSS VSS N l=0.18u w=1.22u
M1 VDD BN net15 VDD P l=0.18u w=1.84u
M2 net17 AN VSS VSS N l=0.18u w=1.22u
M3 VDD AN net17 VDD P l=0.18u w=1.82u
M4 VDD D Y VDD P l=0.18u w=3.64u
M5 VDD C Y VDD P l=0.18u w=3.64u
M6 VDD net15 Y VDD P l=0.18u w=3.64u
M7 VDD net17 Y VDD P l=0.18u w=3.64u
M8 hnet20 D VSS VSS N l=0.18u w=1.04u
M9 hnet19 C hnet20 VSS N l=0.18u w=1.04u
M10 hnet21 net15 hnet19 VSS N l=0.18u w=1.04u
M11 Y net17 hnet21 VSS N l=0.18u w=1.04u
M12 hnet28 D VSS VSS N l=0.18u w=1.04u
M13 hnet30 C hnet28 VSS N l=0.18u w=1.04u
M14 hnet26 net15 hnet30 VSS N l=0.18u w=1.04u
M15 Y net17 hnet26 VSS N l=0.18u w=1.04u
M16 hnet24 D VSS VSS N l=0.18u w=1.04u
M17 hnet22 C hnet24 VSS N l=0.18u w=1.04u
M18 hnet18 net15 hnet22 VSS N l=0.18u w=1.04u
M19 Y net17 hnet18 VSS N l=0.18u w=1.04u
M20 hnet33 D VSS VSS N l=0.18u w=1.04u
M21 hnet27 C hnet33 VSS N l=0.18u w=1.04u
M22 hnet23 net15 hnet27 VSS N l=0.18u w=1.04u
M23 Y net17 hnet23 VSS N l=0.18u w=1.04u
.ends NAND4BBX4
*.SCALE meter
.GLOBAL GND VSS VDD

.subckt NAND4BBXL Y AN BN C D
M0 net15 BN VSS VSS N l=0.18u w=0.3u
M1 VDD BN net15 VDD P l=0.18u w=0.42u
M2 net17 AN VSS VSS N l=0.18u w=0.3u
M3 VDD AN net17 VDD P l=0.18u w=0.42u
M4 VDD D Y VDD P l=0.18u w=0.64u
M5 VDD C Y VDD P l=0.18u w=0.64u
M6 VDD net15 Y VDD P l=0.18u w=0.64u
M7 VDD net17 Y VDD P l=0.18u w=0.64u
M8 hnet20 D VSS VSS N l=0.18u w=0.72u
M9 hnet18 C hnet20 VSS N l=0.18u w=0.72u
M10 hnet19 net15 hnet18 VSS N l=0.18u w=0.72u
M11 Y net17 hnet19 VSS N l=0.18u w=0.72u
.ends NAND4BBXL
*.SCALE meter
.GLOBAL GND VSS VDD

.subckt NAND4BX1 Y AN B C D
M0 net14 AN VSS VSS N l=0.18u w=0.3u
M1 VDD AN net14 VDD P l=0.18u w=0.44u
M2 VDD D Y VDD P l=0.18u w=0.96u
M3 VDD C Y VDD P l=0.18u w=0.96u
M4 VDD B Y VDD P l=0.18u w=0.96u
M5 VDD net14 Y VDD P l=0.18u w=0.96u
M6 hnet15 D VSS VSS N l=0.18u w=1.04u
M7 hnet13 C hnet15 VSS N l=0.18u w=1.04u
M8 hnet14 B hnet13 VSS N l=0.18u w=1.04u
M9 Y net14 hnet14 VSS N l=0.18u w=1.04u
.ends NAND4BX1
*.SCALE meter
.GLOBAL GND VSS VDD

.subckt NAND4BX2 Y AN B C D
M0 net14 AN VSS VSS N l=0.18u w=0.62u
M1 VDD AN net14 VDD P l=0.18u w=0.92u
M2 VDD D Y VDD P l=0.18u w=1.82u
M3 VDD C Y VDD P l=0.18u w=1.82u
M4 VDD B Y VDD P l=0.18u w=1.82u
M5 VDD net14 Y VDD P l=0.18u w=1.82u
M6 hnet15 D VSS VSS N l=0.18u w=1.04u
M7 hnet14 C hnet15 VSS N l=0.18u w=1.04u
M8 hnet13 B hnet14 VSS N l=0.18u w=1.04u
M9 Y net14 hnet13 VSS N l=0.18u w=1.04u
M10 hnet18 D VSS VSS N l=0.18u w=1.04u
M11 hnet22 C hnet18 VSS N l=0.18u w=1.04u
M12 hnet17 B hnet22 VSS N l=0.18u w=1.04u
M13 Y net14 hnet17 VSS N l=0.18u w=1.04u
.ends NAND4BX2
*.SCALE meter
.GLOBAL GND VSS VDD

.subckt NAND4BX4 Y AN B C D
M0 net14 AN VSS VSS N l=0.18u w=1.22u
M1 VDD AN net14 VDD P l=0.18u w=1.82u
M2 VDD D Y VDD P l=0.18u w=3.64u
M3 VDD C Y VDD P l=0.18u w=3.64u
M4 VDD B Y VDD P l=0.18u w=3.64u
M5 VDD net14 Y VDD P l=0.18u w=3.64u
M6 hnet15 D VSS VSS N l=0.18u w=1.04u
M7 hnet14 C hnet15 VSS N l=0.18u w=1.04u
M8 hnet16 B hnet14 VSS N l=0.18u w=1.04u
M9 Y net14 hnet16 VSS N l=0.18u w=1.04u
M10 hnet23 D VSS VSS N l=0.18u w=1.04u
M11 hnet25 C hnet23 VSS N l=0.18u w=1.04u
M12 hnet21 B hnet25 VSS N l=0.18u w=1.04u
M13 Y net14 hnet21 VSS N l=0.18u w=1.04u
M14 hnet19 D VSS VSS N l=0.18u w=1.04u
M15 hnet17 C hnet19 VSS N l=0.18u w=1.04u
M16 hnet13 B hnet17 VSS N l=0.18u w=1.04u
M17 Y net14 hnet13 VSS N l=0.18u w=1.04u
M18 hnet28 D VSS VSS N l=0.18u w=1.04u
M19 hnet22 C hnet28 VSS N l=0.18u w=1.04u
M20 hnet18 B hnet22 VSS N l=0.18u w=1.04u
M21 Y net14 hnet18 VSS N l=0.18u w=1.04u
.ends NAND4BX4
*.SCALE meter
.GLOBAL GND VSS VDD

.subckt NAND4BXL Y AN B C D
M0 net14 AN VSS VSS N l=0.18u w=0.3u
M1 VDD AN net14 VDD P l=0.18u w=0.42u
M2 VDD D Y VDD P l=0.18u w=0.64u
M3 VDD C Y VDD P l=0.18u w=0.64u
M4 VDD B Y VDD P l=0.18u w=0.64u
M5 VDD net14 Y VDD P l=0.18u w=0.64u
M6 hnet15 D VSS VSS N l=0.18u w=0.72u
M7 hnet13 C hnet15 VSS N l=0.18u w=0.72u
M8 hnet14 B hnet13 VSS N l=0.18u w=0.72u
M9 Y net14 hnet14 VSS N l=0.18u w=0.72u
.ends NAND4BXL
*.SCALE meter
.GLOBAL GND VSS VDD

.subckt NAND4X1 Y A B C D
M0 VDD D Y VDD P l=0.18u w=0.96u
M1 VDD C Y VDD P l=0.18u w=0.96u
M2 VDD B Y VDD P l=0.18u w=0.96u
M3 VDD A Y VDD P l=0.18u w=0.96u
M4 hnet10 D VSS VSS N l=0.18u w=1.04u
M5 hnet8 C hnet10 VSS N l=0.18u w=1.04u
M6 hnet9 B hnet8 VSS N l=0.18u w=1.04u
M7 Y A hnet9 VSS N l=0.18u w=1.04u
.ends NAND4X1
*.SCALE meter
.GLOBAL GND VSS VDD

.subckt NAND4X2 Y A B C D
M0 VDD D Y VDD P l=0.18u w=1.82u
M1 VDD C Y VDD P l=0.18u w=1.82u
M2 VDD B Y VDD P l=0.18u w=1.82u
M3 VDD A Y VDD P l=0.18u w=1.82u
M4 hnet10 D VSS VSS N l=0.18u w=1.04u
M5 hnet9 C hnet10 VSS N l=0.18u w=1.04u
M6 hnet8 B hnet9 VSS N l=0.18u w=1.04u
M7 Y A hnet8 VSS N l=0.18u w=1.04u
M8 hnet14 D VSS VSS N l=0.18u w=1.04u
M9 hnet19 C hnet14 VSS N l=0.18u w=1.04u
M10 hnet12 B hnet19 VSS N l=0.18u w=1.04u
M11 Y A hnet12 VSS N l=0.18u w=1.04u
.ends NAND4X2
*.SCALE meter
.GLOBAL GND VSS VDD

.subckt NAND4X4 Y A B C D
M0 VDD D Y VDD P l=0.18u w=3.64u
M1 VDD C Y VDD P l=0.18u w=3.64u
M2 VDD B Y VDD P l=0.18u w=3.64u
M3 VDD A Y VDD P l=0.18u w=3.64u
M4 hnet10 D VSS VSS N l=0.18u w=1.04u
M5 hnet9 C hnet10 VSS N l=0.18u w=1.04u
M6 hnet11 B hnet9 VSS N l=0.18u w=1.04u
M7 Y A hnet11 VSS N l=0.18u w=1.04u
M8 hnet19 D VSS VSS N l=0.18u w=1.04u
M9 hnet21 C hnet19 VSS N l=0.18u w=1.04u
M10 hnet16 B hnet21 VSS N l=0.18u w=1.04u
M11 Y A hnet16 VSS N l=0.18u w=1.04u
M12 hnet14 D VSS VSS N l=0.18u w=1.04u
M13 hnet12 C hnet14 VSS N l=0.18u w=1.04u
M14 hnet8 B hnet12 VSS N l=0.18u w=1.04u
M15 Y A hnet8 VSS N l=0.18u w=1.04u
M16 hnet25 D VSS VSS N l=0.18u w=1.04u
M17 hnet17 C hnet25 VSS N l=0.18u w=1.04u
M18 hnet13 B hnet17 VSS N l=0.18u w=1.04u
M19 Y A hnet13 VSS N l=0.18u w=1.04u
.ends NAND4X4
*.SCALE meter
.GLOBAL GND VSS VDD

.subckt NAND4XL Y A B C D
M0 VDD D Y VDD P l=0.18u w=0.64u
M1 VDD C Y VDD P l=0.18u w=0.64u
M2 VDD B Y VDD P l=0.18u w=0.64u
M3 VDD A Y VDD P l=0.18u w=0.64u
M4 hnet10 D VSS VSS N l=0.18u w=0.72u
M5 hnet8 C hnet10 VSS N l=0.18u w=0.72u
M6 hnet9 B hnet8 VSS N l=0.18u w=0.72u
M7 Y A hnet9 VSS N l=0.18u w=0.72u
.ends NAND4XL
*.SCALE meter
.GLOBAL GND VSS VDD

.subckt NOR2BX1 Y AN B
M0 net9 AN VSS VSS N l=0.18u w=0.3u
M1 VDD AN net9 VDD P l=0.18u w=0.42u
M2 VDD B hnet12 VDD P l=0.18u w=1.2u
M3 hnet12 net9 Y VDD P l=0.18u w=1.2u
M4 Y B VSS VSS N l=0.18u w=0.6u
M5 Y net9 VSS VSS N l=0.18u w=0.6u
.ends NOR2BX1
*.SCALE meter
.GLOBAL GND VSS VDD

.subckt NOR2BX2 Y AN B
M0 net9 AN VSS VSS N l=0.18u w=0.58u
M1 VDD AN net9 VDD P l=0.18u w=0.88u
M2 VDD B hnet13 VDD P l=0.18u w=1.2u
M3 hnet13 net9 Y VDD P l=0.18u w=1.2u
M4 VDD B hnet11 VDD P l=0.18u w=1.2u
M5 hnet11 net9 Y VDD P l=0.18u w=1.2u
M6 Y B VSS VSS N l=0.18u w=1.2u
M7 Y net9 VSS VSS N l=0.18u w=1.2u
.ends NOR2BX2
*.SCALE meter
.GLOBAL GND VSS VDD

.subckt NOR2BX4 Y AN B
M0 Y B VSS VSS N l=0.18u w=2.4u
M1 Y net30 VSS VSS N l=0.18u w=2.4u
M2 VDD B hnet11 VDD P l=0.18u w=1.6u
M3 hnet11 net30 Y VDD P l=0.18u w=1.6u
M4 VDD B hnet16 VDD P l=0.18u w=1.6u
M5 hnet16 net30 Y VDD P l=0.18u w=1.6u
M6 VDD B hnet21 VDD P l=0.18u w=1.58u
M7 hnet21 net30 Y VDD P l=0.18u w=1.58u
M8 net30 AN VSS VSS N l=0.18u w=1.14u
M9 VDD AN net30 VDD P l=0.18u w=1.67u
.ends NOR2BX4
*.SCALE meter
.GLOBAL GND VSS VDD

.subckt NOR2BXL Y AN B
M0 net9 AN VSS VSS N l=0.18u w=0.3u
M1 VDD AN net9 VDD P l=0.18u w=0.42u
M2 VDD B hnet12 VDD P l=0.18u w=0.84u
M3 hnet12 net9 Y VDD P l=0.18u w=0.84u
M4 Y B VSS VSS N l=0.18u w=0.42u
M5 Y net9 VSS VSS N l=0.18u w=0.42u
.ends NOR2BXL
*.SCALE meter
.GLOBAL GND VSS VDD

.subckt NOR2X1 Y A B
M0 VDD B hnet7 VDD P l=0.18u w=1.2u
M1 hnet7 A Y VDD P l=0.18u w=1.2u
M2 Y B VSS VSS N l=0.18u w=0.6u
M3 Y A VSS VSS N l=0.18u w=0.6u
.ends NOR2X1
*.SCALE meter
.GLOBAL GND VSS VDD

.subckt NOR2X2 Y A B
M0 VDD B hnet8 VDD P l=0.18u w=1.2u
M1 hnet8 A Y VDD P l=0.18u w=1.2u
M2 VDD B hnet6 VDD P l=0.18u w=1.2u
M3 hnet6 A Y VDD P l=0.18u w=1.2u
M4 Y B VSS VSS N l=0.18u w=1.2u
M5 Y A VSS VSS N l=0.18u w=1.2u
.ends NOR2X2
*.SCALE meter
.GLOBAL GND VSS VDD

.subckt NOR2X4 Y A B
M0 Y B VSS VSS N l=0.18u w=2.4u
M1 Y A VSS VSS N l=0.18u w=2.4u
M2 VDD B hnet10 VDD P l=0.18u w=1.6u
M3 hnet10 A Y VDD P l=0.18u w=1.6u
M4 VDD B hnet15 VDD P l=0.18u w=1.6u
M5 hnet15 A Y VDD P l=0.18u w=1.6u
M6 VDD B hnet20 VDD P l=0.18u w=1.56u
M7 hnet20 A Y VDD P l=0.18u w=1.56u
.ends NOR2X4
*.SCALE meter
.GLOBAL GND VSS VDD

.subckt NOR2XL Y A B
M0 VDD B hnet7 VDD P l=0.18u w=0.84u
M1 hnet7 A Y VDD P l=0.18u w=0.84u
M2 Y B VSS VSS N l=0.18u w=0.4u
M3 Y A VSS VSS N l=0.18u w=0.4u
.ends NOR2XL
*.SCALE meter
.GLOBAL GND VSS VDD

.subckt NOR3BX1 Y AN B C
M0 net12 AN VSS VSS N l=0.18u w=0.32u
M1 VDD AN net12 VDD P l=0.18u w=0.48u
M2 VDD C hnet17 VDD P l=0.18u w=1.4u
M3 hnet17 B hnet16 VDD P l=0.18u w=1.4u
M4 hnet16 net12 Y VDD P l=0.18u w=1.4u
M5 Y C VSS VSS N l=0.18u w=0.6u
M6 Y B VSS VSS N l=0.18u w=0.6u
M7 Y net12 VSS VSS N l=0.18u w=0.6u
.ends NOR3BX1
*.SCALE meter
.GLOBAL GND VSS VDD

.subckt NOR3BX2 Y AN B C
M0 net12 AN VSS VSS N l=0.18u w=0.64u
M1 VDD AN net12 VDD P l=0.18u w=0.96u
M2 VDD C hnet19 VDD P l=0.18u w=1.4u
M3 hnet19 B hnet15 VDD P l=0.18u w=1.4u
M4 hnet15 net12 Y VDD P l=0.18u w=1.4u
M5 VDD C hnet14 VDD P l=0.18u w=1.4u
M6 hnet14 B hnet12 VDD P l=0.18u w=1.4u
M7 hnet12 net12 Y VDD P l=0.18u w=1.4u
M8 Y C VSS VSS N l=0.18u w=1.2u
M9 Y B VSS VSS N l=0.18u w=1.2u
M10 Y net12 VSS VSS N l=0.18u w=1.2u
.ends NOR3BX2
*.SCALE meter
.GLOBAL GND VSS VDD

.subckt NOR3BX4 Y AN B C
M0 VDD C hnet9 VDD P l=0.18u w=1.73u
M1 hnet9 B hnet12 VDD P l=0.18u w=1.73u
M2 hnet12 net42 Y VDD P l=0.18u w=1.73u
M3 VDD C hnet16 VDD P l=0.18u w=1.6u
M4 hnet16 B hnet19 VDD P l=0.18u w=1.6u
M5 hnet19 net42 Y VDD P l=0.18u w=1.6u
M6 VDD C hnet23 VDD P l=0.18u w=1.47u
M7 hnet23 B hnet26 VDD P l=0.18u w=1.47u
M8 hnet26 net42 Y VDD P l=0.18u w=1.47u
M9 Y C VSS VSS N l=0.18u w=2.04u
M10 Y B VSS VSS N l=0.18u w=2.04u
M11 Y net42 VSS VSS N l=0.18u w=2.04u
M12 net42 AN VSS VSS N l=0.18u w=1.12u
M13 VDD AN net42 VDD P l=0.18u w=1.6u
.ends NOR3BX4
*.SCALE meter
.GLOBAL GND VSS VDD

.subckt NOR3BXL Y AN B C
M0 net12 AN VSS VSS N l=0.18u w=0.3u
M1 VDD AN net12 VDD P l=0.18u w=0.42u
M2 VDD C hnet17 VDD P l=0.18u w=0.98u
M3 hnet17 B hnet16 VDD P l=0.18u w=0.98u
M4 hnet16 net12 Y VDD P l=0.18u w=0.98u
M5 Y C VSS VSS N l=0.18u w=0.42u
M6 Y B VSS VSS N l=0.18u w=0.42u
M7 Y net12 VSS VSS N l=0.18u w=0.42u
.ends NOR3BXL
*.SCALE meter
.GLOBAL GND VSS VDD

.subckt NOR3X1 Y A B C
M0 VDD C hnet14 VDD P l=0.18u w=1.4u
M1 hnet14 B hnet13 VDD P l=0.18u w=1.4u
M2 hnet13 A Y VDD P l=0.18u w=1.4u
M3 Y C VSS VSS N l=0.18u w=0.6u
M4 Y B VSS VSS N l=0.18u w=0.6u
M5 Y A VSS VSS N l=0.18u w=0.6u
.ends NOR3X1
*.SCALE meter
.GLOBAL GND VSS VDD

.subckt NOR3X2 Y A B C
M0 VDD C hnet16 VDD P l=0.18u w=1.4u
M1 hnet16 B hnet11 VDD P l=0.18u w=1.4u
M2 hnet11 A Y VDD P l=0.18u w=1.4u
M3 VDD C hnet9 VDD P l=0.18u w=1.4u
M4 hnet9 B hnet7 VDD P l=0.18u w=1.4u
M5 hnet7 A Y VDD P l=0.18u w=1.4u
M6 Y C VSS VSS N l=0.18u w=1.2u
M7 Y B VSS VSS N l=0.18u w=1.2u
M8 Y A VSS VSS N l=0.18u w=1.2u
.ends NOR3X2
*.SCALE meter
.GLOBAL GND VSS VDD

.subckt NOR3X4 Y A B C
M0 VDD C hnet18 VDD P l=0.18u w=1.52u
M1 hnet18 B hnet12 VDD P l=0.18u w=1.52u
M2 hnet12 A Y VDD P l=0.18u w=1.52u
M3 VDD C hnet9 VDD P l=0.18u w=1.52u
M4 hnet9 B hnet11 VDD P l=0.18u w=1.52u
M5 hnet11 A Y VDD P l=0.18u w=1.52u
M6 VDD C hnet7 VDD P l=0.18u w=1.52u
M7 hnet7 B hnet17 VDD P l=0.18u w=1.52u
M8 hnet17 A Y VDD P l=0.18u w=1.52u
M9 Y C VSS VSS N l=0.18u w=2.04u
M10 Y B VSS VSS N l=0.18u w=2.04u
M11 Y A VSS VSS N l=0.18u w=2.04u
.ends NOR3X4
*.SCALE meter
.GLOBAL GND VSS VDD

.subckt NOR3XL Y A B C
M0 VDD C hnet14 VDD P l=0.18u w=0.98u
M1 hnet14 B hnet13 VDD P l=0.18u w=0.98u
M2 hnet13 A Y VDD P l=0.18u w=0.98u
M3 Y C VSS VSS N l=0.18u w=0.42u
M4 Y B VSS VSS N l=0.18u w=0.42u
M5 Y A VSS VSS N l=0.18u w=0.42u
.ends NOR3XL
*.SCALE meter
.GLOBAL GND VSS VDD

.subckt NOR4BBX1 Y AN BN C D
M0 VDD D hnet13 VDD P l=0.18u w=1.64u
M1 hnet13 C hnet18 VDD P l=0.18u w=1.64u
M2 hnet18 net20 hnet11 VDD P l=0.18u w=1.64u
M3 hnet11 net22 Y VDD P l=0.18u w=1.64u
M4 Y D VSS VSS N l=0.18u w=0.6u
M5 Y C VSS VSS N l=0.18u w=0.6u
M6 Y net20 VSS VSS N l=0.18u w=0.6u
M7 Y net22 VSS VSS N l=0.18u w=0.6u
M8 net20 BN VSS VSS N l=0.18u w=0.36u
M9 VDD BN net20 VDD P l=0.18u w=0.54u
M10 net22 AN VSS VSS N l=0.18u w=0.36u
M11 VDD AN net22 VDD P l=0.18u w=0.54u
.ends NOR4BBX1
*.SCALE meter
.GLOBAL GND VSS VDD

.subckt NOR4BBX2 Y AN BN C D
M0 VDD D hnet16 VDD P l=0.18u w=1.64u
M1 hnet16 C hnet15 VDD P l=0.18u w=1.64u
M2 hnet15 net20 hnet13 VDD P l=0.18u w=1.64u
M3 hnet13 net22 Y VDD P l=0.18u w=1.64u
M4 VDD D hnet11 VDD P l=0.18u w=1.64u
M5 hnet11 C hnet10 VDD P l=0.18u w=1.64u
M6 hnet10 net20 hnet20 VDD P l=0.18u w=1.64u
M7 hnet20 net22 Y VDD P l=0.18u w=1.64u
M8 Y D VSS VSS N l=0.18u w=1.2u
M9 Y C VSS VSS N l=0.18u w=1.2u
M10 Y net20 VSS VSS N l=0.18u w=1.2u
M11 Y net22 VSS VSS N l=0.18u w=1.2u
M12 net20 BN VSS VSS N l=0.18u w=0.72u
M13 VDD BN net20 VDD P l=0.18u w=1.08u
M14 net22 AN VSS VSS N l=0.18u w=0.72u
M15 VDD AN net22 VDD P l=0.18u w=1.08u
.ends NOR4BBX2
*.SCALE meter
.GLOBAL GND VSS VDD

.subckt NOR4BBX4 Y AN BN C D
M0 VDD D hnet17 VDD P l=0.18u w=1.44u
M1 hnet17 C hnet21 VDD P l=0.18u w=1.44u
M2 hnet21 net20 hnet22 VDD P l=0.18u w=1.44u
M3 hnet22 net22 Y VDD P l=0.18u w=1.44u
M4 VDD D hnet12 VDD P l=0.18u w=1.44u
M5 hnet12 C hnet10 VDD P l=0.18u w=1.44u
M6 hnet10 net20 hnet20 VDD P l=0.18u w=1.44u
M7 hnet20 net22 Y VDD P l=0.18u w=1.44u
M8 VDD D hnet18 VDD P l=0.18u w=1.44u
M9 hnet18 C hnet13 VDD P l=0.18u w=1.44u
M10 hnet13 net20 hnet15 VDD P l=0.18u w=1.44u
M11 hnet15 net22 Y VDD P l=0.18u w=1.44u
M12 VDD D hnet11 VDD P l=0.18u w=1.44u
M13 hnet11 C hnet25 VDD P l=0.18u w=1.44u
M14 hnet25 net20 hnet28 VDD P l=0.18u w=1.44u
M15 hnet28 net22 Y VDD P l=0.18u w=1.44u
M16 Y D VSS VSS N l=0.18u w=2.16u
M17 Y C VSS VSS N l=0.18u w=2.16u
M18 Y net20 VSS VSS N l=0.18u w=2.16u
M19 Y net22 VSS VSS N l=0.18u w=2.16u
M20 net20 BN VSS VSS N l=0.18u w=1.26u
M21 VDD BN net20 VDD P l=0.18u w=1.76u
M22 net22 AN VSS VSS N l=0.18u w=1.26u
M23 VDD AN net22 VDD P l=0.18u w=1.76u
.ends NOR4BBX4
*.SCALE meter
.GLOBAL GND VSS VDD

.subckt NOR4BBXL Y AN BN C D
M0 VDD D hnet13 VDD P l=0.18u w=1.16u
M1 hnet13 C hnet18 VDD P l=0.18u w=1.16u
M2 hnet18 net20 hnet11 VDD P l=0.18u w=1.16u
M3 hnet11 net22 Y VDD P l=0.18u w=1.16u
M4 Y D VSS VSS N l=0.18u w=0.42u
M5 Y C VSS VSS N l=0.18u w=0.42u
M6 Y net20 VSS VSS N l=0.18u w=0.42u
M7 Y net22 VSS VSS N l=0.18u w=0.42u
M8 net20 BN VSS VSS N l=0.18u w=0.3u
M9 VDD BN net20 VDD P l=0.18u w=0.42u
M10 net22 AN VSS VSS N l=0.18u w=0.3u
M11 VDD AN net22 VDD P l=0.18u w=0.42u
.ends NOR4BBXL
*.SCALE meter
.GLOBAL GND VSS VDD

.subckt NOR4BX1 Y AN B C D
M0 VDD D hnet12 VDD P l=0.18u w=1.54u
M1 hnet12 C hnet17 VDD P l=0.18u w=1.54u
M2 hnet17 B hnet10 VDD P l=0.18u w=1.54u
M3 hnet10 net19 Y VDD P l=0.18u w=1.54u
M4 Y D VSS VSS N l=0.18u w=0.6u
M5 Y C VSS VSS N l=0.18u w=0.6u
M6 Y B VSS VSS N l=0.18u w=0.6u
M7 Y net19 VSS VSS N l=0.18u w=0.6u
M8 net19 AN VSS VSS N l=0.18u w=0.36u
M9 VDD AN net19 VDD P l=0.18u w=0.54u
.ends NOR4BX1
*.SCALE meter
.GLOBAL GND VSS VDD

.subckt NOR4BX2 Y AN B C D
M0 VDD D hnet15 VDD P l=0.18u w=1.64u
M1 hnet15 C hnet14 VDD P l=0.18u w=1.64u
M2 hnet14 B hnet12 VDD P l=0.18u w=1.64u
M3 hnet12 net19 Y VDD P l=0.18u w=1.64u
M4 VDD D hnet10 VDD P l=0.18u w=1.64u
M5 hnet10 C hnet9 VDD P l=0.18u w=1.64u
M6 hnet9 B hnet19 VDD P l=0.18u w=1.64u
M7 hnet19 net19 Y VDD P l=0.18u w=1.64u
M8 Y D VSS VSS N l=0.18u w=1.18u
M9 Y C VSS VSS N l=0.18u w=1.18u
M10 Y B VSS VSS N l=0.18u w=1.18u
M11 Y net19 VSS VSS N l=0.18u w=1.18u
M12 net19 AN VSS VSS N l=0.18u w=0.72u
M13 VDD AN net19 VDD P l=0.18u w=1.08u
.ends NOR4BX2
*.SCALE meter
.GLOBAL GND VSS VDD

.subckt NOR4BX4 Y AN B C D
M0 VDD D hnet16 VDD P l=0.18u w=1.44u
M1 hnet16 C hnet20 VDD P l=0.18u w=1.44u
M2 hnet20 B hnet21 VDD P l=0.18u w=1.44u
M3 hnet21 net19 Y VDD P l=0.18u w=1.44u
M4 VDD D hnet11 VDD P l=0.18u w=1.44u
M5 hnet11 C hnet9 VDD P l=0.18u w=1.44u
M6 hnet9 B hnet19 VDD P l=0.18u w=1.44u
M7 hnet19 net19 Y VDD P l=0.18u w=1.44u
M8 VDD D hnet17 VDD P l=0.18u w=1.44u
M9 hnet17 C hnet12 VDD P l=0.18u w=1.44u
M10 hnet12 B hnet14 VDD P l=0.18u w=1.44u
M11 hnet14 net19 Y VDD P l=0.18u w=1.44u
M12 VDD D hnet10 VDD P l=0.18u w=1.44u
M13 hnet10 C hnet24 VDD P l=0.18u w=1.44u
M14 hnet24 B hnet27 VDD P l=0.18u w=1.44u
M15 hnet27 net19 Y VDD P l=0.18u w=1.44u
M16 Y D VSS VSS N l=0.18u w=2.16u
M17 Y C VSS VSS N l=0.18u w=2.16u
M18 Y B VSS VSS N l=0.18u w=2.16u
M19 Y net19 VSS VSS N l=0.18u w=2.16u
M20 net19 AN VSS VSS N l=0.18u w=1.26u
M21 VDD AN net19 VDD P l=0.18u w=1.76u
.ends NOR4BX4
*.SCALE meter
.GLOBAL GND VSS VDD

.subckt NOR4BXL Y AN B C D
M0 VDD D hnet12 VDD P l=0.18u w=1.16u
M1 hnet12 C hnet17 VDD P l=0.18u w=1.16u
M2 hnet17 B hnet10 VDD P l=0.18u w=1.16u
M3 hnet10 net19 Y VDD P l=0.18u w=1.16u
M4 Y D VSS VSS N l=0.18u w=0.42u
M5 Y C VSS VSS N l=0.18u w=0.42u
M6 Y B VSS VSS N l=0.18u w=0.42u
M7 Y net19 VSS VSS N l=0.18u w=0.42u
M8 net19 AN VSS VSS N l=0.18u w=0.3u
M9 VDD AN net19 VDD P l=0.18u w=0.42u
.ends NOR4BXL
*.SCALE meter
.GLOBAL GND VSS VDD

.subckt NOR4X1 Y A B C D
M0 VDD D hnet11 VDD P l=0.18u w=1.64u
M1 hnet11 C hnet16 VDD P l=0.18u w=1.64u
M2 hnet16 B hnet9 VDD P l=0.18u w=1.64u
M3 hnet9 A Y VDD P l=0.18u w=1.64u
M4 Y D VSS VSS N l=0.18u w=0.6u
M5 Y C VSS VSS N l=0.18u w=0.6u
M6 Y B VSS VSS N l=0.18u w=0.6u
M7 Y A VSS VSS N l=0.18u w=0.6u
.ends NOR4X1
*.SCALE meter
.GLOBAL GND VSS VDD

.subckt NOR4X2 Y A B C D
M0 VDD D hnet14 VDD P l=0.18u w=1.64u
M1 hnet14 C hnet13 VDD P l=0.18u w=1.64u
M2 hnet13 B hnet11 VDD P l=0.18u w=1.64u
M3 hnet11 A Y VDD P l=0.18u w=1.64u
M4 VDD D hnet9 VDD P l=0.18u w=1.64u
M5 hnet9 C hnet8 VDD P l=0.18u w=1.64u
M6 hnet8 B hnet18 VDD P l=0.18u w=1.64u
M7 hnet18 A Y VDD P l=0.18u w=1.64u
M8 Y D VSS VSS N l=0.18u w=1.2u
M9 Y C VSS VSS N l=0.18u w=1.2u
M10 Y B VSS VSS N l=0.18u w=1.2u
M11 Y A VSS VSS N l=0.18u w=1.2u
.ends NOR4X2
*.SCALE meter
.GLOBAL GND VSS VDD

.subckt NOR4X4 Y A B C D
M0 VDD D hnet15 VDD P l=0.18u w=1.44u
M1 hnet15 C hnet19 VDD P l=0.18u w=1.44u
M2 hnet19 B hnet20 VDD P l=0.18u w=1.44u
M3 hnet20 A Y VDD P l=0.18u w=1.44u
M4 VDD D hnet10 VDD P l=0.18u w=1.44u
M5 hnet10 C hnet8 VDD P l=0.18u w=1.44u
M6 hnet8 B hnet18 VDD P l=0.18u w=1.44u
M7 hnet18 A Y VDD P l=0.18u w=1.44u
M8 VDD D hnet16 VDD P l=0.18u w=1.44u
M9 hnet16 C hnet11 VDD P l=0.18u w=1.44u
M10 hnet11 B hnet13 VDD P l=0.18u w=1.44u
M11 hnet13 A Y VDD P l=0.18u w=1.44u
M12 VDD D hnet9 VDD P l=0.18u w=1.44u
M13 hnet9 C hnet23 VDD P l=0.18u w=1.44u
M14 hnet23 B hnet26 VDD P l=0.18u w=1.44u
M15 hnet26 A Y VDD P l=0.18u w=1.44u
M16 Y D VSS VSS N l=0.18u w=2.16u
M17 Y C VSS VSS N l=0.18u w=2.16u
M18 Y B VSS VSS N l=0.18u w=2.16u
M19 Y A VSS VSS N l=0.18u w=2.16u
.ends NOR4X4
*.SCALE meter
.GLOBAL GND VSS VDD

.subckt NOR4XL Y A B C D
M0 VDD D hnet11 VDD P l=0.18u w=1.16u
M1 hnet11 C hnet16 VDD P l=0.18u w=1.16u
M2 hnet16 B hnet9 VDD P l=0.18u w=1.16u
M3 hnet9 A Y VDD P l=0.18u w=1.16u
M4 Y D VSS VSS N l=0.18u w=0.42u
M5 Y C VSS VSS N l=0.18u w=0.42u
M6 Y B VSS VSS N l=0.18u w=0.42u
M7 Y A VSS VSS N l=0.18u w=0.42u
.ends NOR4XL
*.SCALE meter
.GLOBAL GND VSS VDD

.subckt OAI211X1 Y A0 A1 B0 C0
M0 VDD A1 hnet15 VDD P l=0.18u w=1.2u
M1 hnet15 A0 Y VDD P l=0.18u w=1.2u
M2 net25 C0 net32 VSS N l=0.18u w=0.96u
M3 Y B0 net25 VSS N l=0.18u w=0.94u
M4 net32 A1 VSS VSS N l=0.18u w=0.96u
M5 net32 A0 VSS VSS N l=0.18u w=0.96u
M6 Y C0 VDD VDD P l=0.18u w=0.9u
M7 Y B0 VDD VDD P l=0.18u w=0.9u
.ends OAI211X1
*.SCALE meter
.GLOBAL GND VSS VDD

.subckt OAI211X2 Y A0 A1 B0 C0
M0 VDD A1 hnet17 VDD P l=0.18u w=1.2u
M1 hnet17 A0 Y VDD P l=0.18u w=1.2u
M2 VDD A1 hnet14 VDD P l=0.18u w=1.2u
M3 hnet14 A0 Y VDD P l=0.18u w=1.2u
M4 net25 C0 net38 VSS N l=0.18u w=0.96u
M5 Y B0 net25 VSS N l=0.18u w=0.96u
M6 net31 C0 net38 VSS N l=0.18u w=0.96u
M7 Y B0 net31 VSS N l=0.18u w=0.96u
M8 net38 A1 VSS VSS N l=0.18u w=1.88u
M9 net38 A0 VSS VSS N l=0.18u w=1.9u
M10 Y C0 VDD VDD P l=0.18u w=1.7u
M11 Y B0 VDD VDD P l=0.18u w=1.7u
.ends OAI211X2
*.SCALE meter
.GLOBAL GND VSS VDD

.subckt OAI211X4 Y A0 A1 B0 C0
M0 net19 net23 VSS VSS N l=0.18u w=0.96u
M1 VDD net23 net19 VDD P l=0.18u w=1.44u
M2 Y net19 VSS VSS N l=0.18u w=2.4u
M3 VDD net19 Y VDD P l=0.18u w=3.6u
M4 VDD A1 hnet21 VDD P l=0.18u w=0.76u
M5 hnet21 A0 net23 VDD P l=0.18u w=0.76u
M6 net30 C0 net37 VSS N l=0.18u w=0.6u
M7 net23 B0 net30 VSS N l=0.18u w=0.6u
M8 net37 A1 VSS VSS N l=0.18u w=0.6u
M9 net37 A0 VSS VSS N l=0.18u w=0.6u
M10 net23 C0 VDD VDD P l=0.18u w=0.58u
M11 net23 B0 VDD VDD P l=0.18u w=0.58u
.ends OAI211X4
*.SCALE meter
.GLOBAL GND VSS VDD

.subckt OAI211XL Y A0 A1 B0 C0
M0 VDD A1 hnet15 VDD P l=0.18u w=0.84u
M1 hnet15 A0 Y VDD P l=0.18u w=0.84u
M2 net25 C0 net32 VSS N l=0.18u w=0.66u
M3 Y B0 net25 VSS N l=0.18u w=0.66u
M4 net32 A1 VSS VSS N l=0.18u w=0.66u
M5 net32 A0 VSS VSS N l=0.18u w=0.66u
M6 Y C0 VDD VDD P l=0.18u w=0.64u
M7 Y B0 VDD VDD P l=0.18u w=0.64u
.ends OAI211XL
*.SCALE meter
.GLOBAL GND VSS VDD

.subckt OAI21X1 Y A0 A1 B0
M0 VDD A1 hnet13 VDD P l=0.18u w=1.2u
M1 hnet13 A0 Y VDD P l=0.18u w=1.2u
M2 Y B0 net25 VSS N l=0.18u w=0.8u
M3 net25 A1 VSS VSS N l=0.18u w=0.8u
M4 net25 A0 VSS VSS N l=0.18u w=0.8u
M5 Y B0 VDD VDD P l=0.18u w=0.9u
.ends OAI21X1
*.SCALE meter
.GLOBAL GND VSS VDD

.subckt OAI21X2 Y A0 A1 B0
M0 VDD A1 hnet14 VDD P l=0.18u w=1.2u
M1 hnet14 A0 Y VDD P l=0.18u w=1.2u
M2 VDD A1 hnet11 VDD P l=0.18u w=1.2u
M3 hnet11 A0 Y VDD P l=0.18u w=1.2u
M4 Y B0 net25 VSS N l=0.18u w=1.58u
M5 net25 A1 VSS VSS N l=0.18u w=1.58u
M6 net25 A0 VSS VSS N l=0.18u w=1.58u
M7 Y B0 VDD VDD P l=0.18u w=1.8u
.ends OAI21X2
*.SCALE meter
.GLOBAL GND VSS VDD

.subckt OAI21X4 Y A0 A1 B0
M0 VDD A1 hnet14 VDD P l=0.18u w=1.6u
M1 hnet14 A0 Y VDD P l=0.18u w=1.6u
M2 VDD A1 hnet12 VDD P l=0.18u w=1.6u
M3 hnet12 A0 Y VDD P l=0.18u w=1.6u
M4 VDD A1 hnet10 VDD P l=0.18u w=1.6u
M5 hnet10 A0 Y VDD P l=0.18u w=1.6u
M6 Y B0 net25 VSS N l=0.18u w=3.2u
M7 net25 A1 VSS VSS N l=0.18u w=3.2u
M8 net25 A0 VSS VSS N l=0.18u w=3.2u
M9 Y B0 VDD VDD P l=0.18u w=3.6u
.ends OAI21X4
*.SCALE meter
.GLOBAL GND VSS VDD

.subckt OAI21XL Y A0 A1 B0
M0 VDD A1 hnet13 VDD P l=0.18u w=0.84u
M1 hnet13 A0 Y VDD P l=0.18u w=0.84u
M2 Y B0 net25 VSS N l=0.18u w=0.49u
M3 net25 A1 VSS VSS N l=0.18u w=0.56u
M4 net25 A0 VSS VSS N l=0.18u w=0.56u
M5 Y B0 VDD VDD P l=0.18u w=0.64u
.ends OAI21XL
*.SCALE meter
.GLOBAL GND VSS VDD

.subckt OAI221X1 Y A0 A1 B0 B1 C0
M0 VDD B1 hnet16 VDD P l=0.18u w=1.2u
M1 hnet16 B0 Y VDD P l=0.18u w=1.2u
M2 VDD A1 hnet20 VDD P l=0.18u w=1.2u
M3 hnet20 A0 Y VDD P l=0.18u w=1.2u
M4 Y C0 VDD VDD P l=0.18u w=0.9u
M5 Y C0 net42 VSS N l=0.18u w=0.96u
M6 net42 A0 net48 VSS N l=0.18u w=0.96u
M7 net42 A1 net48 VSS N l=0.18u w=0.96u
M8 net48 B0 VSS VSS N l=0.18u w=0.96u
M9 net48 B1 VSS VSS N l=0.18u w=0.96u
.ends OAI221X1
*.SCALE meter
.GLOBAL GND VSS VDD

.subckt OAI221X2 Y A0 A1 B0 B1 C0
M0 VDD B1 hnet17 VDD P l=0.18u w=1.2u
M1 hnet17 B0 Y VDD P l=0.18u w=1.2u
M2 VDD B1 hnet14 VDD P l=0.18u w=1.2u
M3 hnet14 B0 Y VDD P l=0.18u w=1.2u
M4 VDD A1 hnet22 VDD P l=0.18u w=1.2u
M5 hnet22 A0 Y VDD P l=0.18u w=1.2u
M6 VDD A1 hnet19 VDD P l=0.18u w=1.2u
M7 hnet19 A0 Y VDD P l=0.18u w=1.2u
M8 Y C0 VDD VDD P l=0.18u w=1.8u
M9 Y C0 net42 VSS N l=0.18u w=1.92u
M10 net42 A0 net48 VSS N l=0.18u w=1.9u
M11 net42 A1 net48 VSS N l=0.18u w=1.9u
M12 net48 B0 VSS VSS N l=0.18u w=1.92u
M13 net48 B1 VSS VSS N l=0.18u w=1.92u
.ends OAI221X2
*.SCALE meter
.GLOBAL GND VSS VDD

.subckt OAI221X4 Y A0 A1 B0 B1 C0
M0 net26 net30 VSS VSS N l=0.18u w=0.96u
M1 VDD net30 net26 VDD P l=0.18u w=1.44u
M2 Y net26 VSS VSS N l=0.18u w=2.4u
M3 VDD net26 Y VDD P l=0.18u w=3.4u
M4 VDD B1 hnet22 VDD P l=0.18u w=0.76u
M5 hnet22 B0 net30 VDD P l=0.18u w=0.76u
M6 VDD A1 hnet26 VDD P l=0.18u w=0.76u
M7 hnet26 A0 net30 VDD P l=0.18u w=0.76u
M8 net30 C0 VDD VDD P l=0.18u w=0.58u
M9 net30 C0 net47 VSS N l=0.18u w=0.62u
M10 net47 A0 net53 VSS N l=0.18u w=0.62u
M11 net47 A1 net53 VSS N l=0.18u w=0.62u
M12 net53 B0 VSS VSS N l=0.18u w=0.62u
M13 net53 B1 VSS VSS N l=0.18u w=0.62u
.ends OAI221X4
*.SCALE meter
.GLOBAL GND VSS VDD

.subckt OAI221XL Y A0 A1 B0 B1 C0
M0 VDD B1 hnet16 VDD P l=0.18u w=0.84u
M1 hnet16 B0 Y VDD P l=0.18u w=0.84u
M2 VDD A1 hnet20 VDD P l=0.18u w=0.84u
M3 hnet20 A0 Y VDD P l=0.18u w=0.84u
M4 Y C0 VDD VDD P l=0.18u w=0.64u
M5 Y C0 net42 VSS N l=0.18u w=0.66u
M6 net42 A0 net48 VSS N l=0.18u w=0.66u
M7 net42 A1 net48 VSS N l=0.18u w=0.66u
M8 net48 B0 VSS VSS N l=0.18u w=0.66u
M9 net48 B1 VSS VSS N l=0.18u w=0.66u
.ends OAI221XL
*.SCALE meter
.GLOBAL GND VSS VDD

.subckt OAI222X1 Y A0 A1 B0 B1 C0 C1
M0 VDD B1 hnet16 VDD P l=0.18u w=1.2u
M1 hnet16 B0 Y VDD P l=0.18u w=1.2u
M2 VDD A1 hnet21 VDD P l=0.18u w=1.2u
M3 hnet21 A0 Y VDD P l=0.18u w=1.2u
M4 VDD C1 hnet26 VDD P l=0.18u w=1.2u
M5 hnet26 C0 Y VDD P l=0.18u w=1.2u
M6 Y C0 net49 VSS N l=0.18u w=0.96u
M7 Y C1 net49 VSS N l=0.18u w=0.96u
M8 net49 A0 net55 VSS N l=0.18u w=0.96u
M9 net49 A1 net55 VSS N l=0.18u w=0.96u
M10 net55 B0 VSS VSS N l=0.18u w=0.96u
M11 net55 B1 VSS VSS N l=0.18u w=0.96u
.ends OAI222X1
*.SCALE meter
.GLOBAL GND VSS VDD

.subckt OAI222X2 Y A0 A1 B0 B1 C0 C1
M0 VDD B1 hnet18 VDD P l=0.18u w=1.2u
M1 hnet18 B0 Y VDD P l=0.18u w=1.2u
M2 VDD B1 hnet14 VDD P l=0.18u w=1.2u
M3 hnet14 B0 Y VDD P l=0.18u w=1.2u
M4 VDD A1 hnet24 VDD P l=0.18u w=1.2u
M5 hnet24 A0 Y VDD P l=0.18u w=1.2u
M6 VDD A1 hnet20 VDD P l=0.18u w=1.2u
M7 hnet20 A0 Y VDD P l=0.18u w=1.2u
M8 VDD C1 hnet30 VDD P l=0.18u w=1.2u
M9 hnet30 C0 Y VDD P l=0.18u w=1.2u
M10 VDD C1 hnet26 VDD P l=0.18u w=1.2u
M11 hnet26 C0 Y VDD P l=0.18u w=1.2u
M12 Y C0 net49 VSS N l=0.18u w=1.92u
M13 Y C1 net49 VSS N l=0.18u w=1.92u
M14 net49 A0 net55 VSS N l=0.18u w=1.98u
M15 net49 A1 net55 VSS N l=0.18u w=1.98u
M16 net55 B0 VSS VSS N l=0.18u w=1.9u
M17 net55 B1 VSS VSS N l=0.18u w=1.9u
.ends OAI222X2
*.SCALE meter
.GLOBAL GND VSS VDD

.subckt OAI222X4 Y A0 A1 B0 B1 C0 C1
M0 net30 net34 VSS VSS N l=0.18u w=0.96u
M1 VDD net34 net30 VDD P l=0.18u w=1.44u
M2 Y net30 VSS VSS N l=0.18u w=2.4u
M3 VDD net30 Y VDD P l=0.18u w=3.4u
M4 VDD B1 hnet24 VDD P l=0.18u w=0.76u
M5 hnet24 B0 net34 VDD P l=0.18u w=0.76u
M6 VDD A1 hnet28 VDD P l=0.18u w=0.76u
M7 hnet28 A0 net34 VDD P l=0.18u w=0.76u
M8 VDD C1 hnet32 VDD P l=0.18u w=0.76u
M9 hnet32 C0 net34 VDD P l=0.18u w=0.76u
M10 net34 C0 net54 VSS N l=0.18u w=0.6u
M11 net34 C1 net54 VSS N l=0.18u w=0.6u
M12 net54 A0 net60 VSS N l=0.18u w=0.6u
M13 net54 A1 net60 VSS N l=0.18u w=0.6u
M14 net60 B0 VSS VSS N l=0.18u w=0.6u
M15 net60 B1 VSS VSS N l=0.18u w=0.6u
.ends OAI222X4
*.SCALE meter
.GLOBAL GND VSS VDD

.subckt OAI222XL Y A0 A1 B0 B1 C0 C1
M0 VDD B1 hnet16 VDD P l=0.18u w=0.84u
M1 hnet16 B0 Y VDD P l=0.18u w=0.84u
M2 VDD A1 hnet21 VDD P l=0.18u w=0.84u
M3 hnet21 A0 Y VDD P l=0.18u w=0.84u
M4 VDD C1 hnet26 VDD P l=0.18u w=0.84u
M5 hnet26 C0 Y VDD P l=0.18u w=0.84u
M6 Y C0 net49 VSS N l=0.18u w=0.66u
M7 Y C1 net49 VSS N l=0.18u w=0.66u
M8 net49 A0 net55 VSS N l=0.18u w=0.66u
M9 net49 A1 net55 VSS N l=0.18u w=0.66u
M10 net55 B0 VSS VSS N l=0.18u w=0.66u
M11 net55 B1 VSS VSS N l=0.18u w=0.66u
.ends OAI222XL
*.SCALE meter
.GLOBAL GND VSS VDD

.subckt OAI22X1 Y A0 A1 B0 B1
M0 VDD B1 hnet13 VDD P l=0.18u w=1.2u
M1 hnet13 B0 Y VDD P l=0.18u w=1.2u
M2 VDD A1 hnet18 VDD P l=0.18u w=1.2u
M3 hnet18 A0 Y VDD P l=0.18u w=1.2u
M4 Y A0 net38 VSS N l=0.18u w=0.8u
M5 Y A1 net38 VSS N l=0.18u w=0.8u
M6 net38 B0 VSS VSS N l=0.18u w=0.8u
M7 net38 B1 VSS VSS N l=0.18u w=0.8u
.ends OAI22X1
*.SCALE meter
.GLOBAL GND VSS VDD

.subckt OAI22X2 Y A0 A1 B0 B1
M0 VDD B1 hnet15 VDD P l=0.18u w=1.2u
M1 hnet15 B0 Y VDD P l=0.18u w=1.2u
M2 VDD B1 hnet11 VDD P l=0.18u w=1.2u
M3 hnet11 B0 Y VDD P l=0.18u w=1.2u
M4 VDD A1 hnet21 VDD P l=0.18u w=1.2u
M5 hnet21 A0 Y VDD P l=0.18u w=1.2u
M6 VDD A1 hnet17 VDD P l=0.18u w=1.2u
M7 hnet17 A0 Y VDD P l=0.18u w=1.2u
M8 Y A0 net38 VSS N l=0.18u w=1.56u
M9 Y A1 net38 VSS N l=0.18u w=1.56u
M10 net38 B0 VSS VSS N l=0.18u w=1.56u
M11 net38 B1 VSS VSS N l=0.18u w=1.56u
.ends OAI22X2
*.SCALE meter
.GLOBAL GND VSS VDD

.subckt OAI22X4 Y A0 A1 B0 B1
M0 VDD B1 hnet15 VDD P l=0.18u w=1.6u
M1 hnet15 B0 Y VDD P l=0.18u w=1.6u
M2 VDD B1 hnet12 VDD P l=0.18u w=1.6u
M3 hnet12 B0 Y VDD P l=0.18u w=1.6u
M4 VDD B1 hnet10 VDD P l=0.18u w=1.6u
M5 hnet10 B0 Y VDD P l=0.18u w=1.6u
M6 VDD A1 hnet22 VDD P l=0.18u w=1.6u
M7 hnet22 A0 Y VDD P l=0.18u w=1.6u
M8 VDD A1 hnet19 VDD P l=0.18u w=1.6u
M9 hnet19 A0 Y VDD P l=0.18u w=1.6u
M10 VDD A1 hnet17 VDD P l=0.18u w=1.6u
M11 hnet17 A0 Y VDD P l=0.18u w=1.6u
M12 Y A0 net38 VSS N l=0.18u w=3.12u
M13 Y A1 net38 VSS N l=0.18u w=3.12u
M14 net38 B0 VSS VSS N l=0.18u w=3.12u
M15 net38 B1 VSS VSS N l=0.18u w=3.12u
.ends OAI22X4
*.SCALE meter
.GLOBAL GND VSS VDD

.subckt OAI22XL Y A0 A1 B0 B1
M0 VDD B1 hnet13 VDD P l=0.18u w=0.84u
M1 hnet13 B0 Y VDD P l=0.18u w=0.84u
M2 VDD A1 hnet18 VDD P l=0.18u w=0.84u
M3 hnet18 A0 Y VDD P l=0.18u w=0.84u
M4 Y A0 net38 VSS N l=0.18u w=0.56u
M5 Y A1 net38 VSS N l=0.18u w=0.56u
M6 net38 B0 VSS VSS N l=0.18u w=0.56u
M7 net38 B1 VSS VSS N l=0.18u w=0.56u
.ends OAI22XL
*.SCALE meter
.GLOBAL GND VSS VDD

.subckt OAI2BB1X1 Y A0N A1N B0
M0 VDD A0N net11 VDD P l=0.18u w=0.4u
M1 VDD A1N net11 VDD P l=0.18u w=0.4u
M2 hnet12 A0N VSS VSS N l=0.18u w=0.36u
M3 net11 A1N hnet12 VSS N l=0.18u w=0.36u
M4 VDD B0 Y VDD P l=0.18u w=0.9u
M5 VDD net11 Y VDD P l=0.18u w=0.9u
M6 hnet18 B0 VSS VSS N l=0.18u w=0.8u
M7 Y net11 hnet18 VSS N l=0.18u w=0.8u
.ends OAI2BB1X1
*.SCALE meter
.GLOBAL GND VSS VDD

.subckt OAI2BB1X2 Y A0N A1N B0
M0 VDD A0N net11 VDD P l=0.18u w=0.82u
M1 VDD A1N net11 VDD P l=0.18u w=0.82u
M2 hnet12 A0N VSS VSS N l=0.18u w=0.72u
M3 net11 A1N hnet12 VSS N l=0.18u w=0.72u
M4 VDD B0 Y VDD P l=0.18u w=1.8u
M5 VDD net11 Y VDD P l=0.18u w=1.8u
M6 hnet18 B0 VSS VSS N l=0.18u w=0.8u
M7 Y net11 hnet18 VSS N l=0.18u w=0.8u
M8 hnet14 B0 VSS VSS N l=0.18u w=0.8u
M9 Y net11 hnet14 VSS N l=0.18u w=0.8u
.ends OAI2BB1X2
*.SCALE meter
.GLOBAL GND VSS VDD

.subckt OAI2BB1X4 Y A0N A1N B0
M0 Y net46 net38 VSS N l=0.18u w=0.78u
M1 Y net46 net38 VSS N l=0.18u w=1.2u
M2 Y net46 net38 VSS N l=0.18u w=1.2u
M3 net38 B0 VSS VSS N l=0.18u w=0.78u
M4 net38 B0 VSS VSS N l=0.18u w=1.2u
M5 net38 B0 VSS VSS N l=0.18u w=1.2u
M6 Y net46 VDD VDD P l=0.18u w=3.6u
M7 Y B0 VDD VDD P l=0.18u w=3.6u
M8 VDD A0N net46 VDD P l=0.18u w=1.64u
M9 VDD A1N net46 VDD P l=0.18u w=1.64u
M10 hnet14 A0N VSS VSS N l=0.18u w=1.27u
M11 net46 A1N hnet14 VSS N l=0.18u w=1.27u
.ends OAI2BB1X4
*.SCALE meter
.GLOBAL GND VSS VDD

.subckt OAI2BB1XL Y A0N A1N B0
M0 VDD A0N net11 VDD P l=0.18u w=0.42u
M1 VDD A1N net11 VDD P l=0.18u w=0.42u
M2 hnet12 A0N VSS VSS N l=0.18u w=0.36u
M3 net11 A1N hnet12 VSS N l=0.18u w=0.36u
M4 VDD B0 Y VDD P l=0.18u w=0.64u
M5 VDD net11 Y VDD P l=0.18u w=0.64u
M6 hnet18 B0 VSS VSS N l=0.18u w=0.56u
M7 Y net11 hnet18 VSS N l=0.18u w=0.56u
.ends OAI2BB1XL
*.SCALE meter
.GLOBAL GND VSS VDD

.subckt OAI2BB2X1 Y A0N A1N B0 B1
M0 VDD B1 hnet15 VDD P l=0.18u w=1.2u
M1 hnet15 B0 Y VDD P l=0.18u w=1.2u
M2 VDD A0N net27 VDD P l=0.18u w=0.4u
M3 VDD A1N net27 VDD P l=0.18u w=0.4u
M4 hnet19 A0N VSS VSS N l=0.18u w=0.36u
M5 net27 A1N hnet19 VSS N l=0.18u w=0.36u
M6 Y net27 VDD VDD P l=0.18u w=0.9u
M7 net34 B0 VSS VSS N l=0.18u w=0.8u
M8 Y net27 net34 VSS N l=0.18u w=0.8u
M9 net34 B1 VSS VSS N l=0.18u w=0.8u
.ends OAI2BB2X1
*.SCALE meter
.GLOBAL GND VSS VDD

.subckt OAI2BB2X2 Y A0N A1N B0 B1
M0 VDD B1 hnet16 VDD P l=0.18u w=1.2u
M1 hnet16 B0 Y VDD P l=0.18u w=1.2u
M2 VDD B1 hnet13 VDD P l=0.18u w=1.2u
M3 hnet13 B0 Y VDD P l=0.18u w=1.2u
M4 VDD A0N net27 VDD P l=0.18u w=0.8u
M5 VDD A1N net27 VDD P l=0.18u w=0.8u
M6 hnet20 A0N VSS VSS N l=0.18u w=0.7u
M7 net27 A1N hnet20 VSS N l=0.18u w=0.7u
M8 Y net27 VDD VDD P l=0.18u w=1.8u
M9 net34 B0 VSS VSS N l=0.18u w=1.58u
M10 Y net27 net34 VSS N l=0.18u w=1.58u
M11 net34 B1 VSS VSS N l=0.18u w=1.58u
.ends OAI2BB2X2
*.SCALE meter
.GLOBAL GND VSS VDD

.subckt OAI2BB2X4 Y A0N A1N B0 B1
M0 VDD B1 hnet16 VDD P l=0.18u w=1.6u
M1 hnet16 B0 Y VDD P l=0.18u w=1.6u
M2 VDD B1 hnet14 VDD P l=0.18u w=1.6u
M3 hnet14 B0 Y VDD P l=0.18u w=1.6u
M4 VDD B1 hnet12 VDD P l=0.18u w=1.6u
M5 hnet12 B0 Y VDD P l=0.18u w=1.6u
M6 VDD A0N net27 VDD P l=0.18u w=1.64u
M7 VDD A1N net27 VDD P l=0.18u w=1.64u
M8 hnet22 A0N VSS VSS N l=0.18u w=0.72u
M9 net27 A1N hnet22 VSS N l=0.18u w=0.72u
M10 hnet18 A0N VSS VSS N l=0.18u w=0.72u
M11 net27 A1N hnet18 VSS N l=0.18u w=0.72u
M12 Y net27 VDD VDD P l=0.18u w=3.6u
M13 net34 B0 VSS VSS N l=0.18u w=3.16u
M14 Y net27 net34 VSS N l=0.18u w=3.16u
M15 net34 B1 VSS VSS N l=0.18u w=3.16u
.ends OAI2BB2X4
*.SCALE meter
.GLOBAL GND VSS VDD

.subckt OAI2BB2XL Y A0N A1N B0 B1
M0 VDD B1 hnet15 VDD P l=0.18u w=0.84u
M1 hnet15 B0 Y VDD P l=0.18u w=0.84u
M2 VDD A0N net27 VDD P l=0.18u w=0.42u
M3 VDD A1N net27 VDD P l=0.18u w=0.42u
M4 hnet19 A0N VSS VSS N l=0.18u w=0.36u
M5 net27 A1N hnet19 VSS N l=0.18u w=0.36u
M6 Y net27 VDD VDD P l=0.18u w=0.64u
M7 net34 B0 VSS VSS N l=0.18u w=0.56u
M8 Y net27 net34 VSS N l=0.18u w=0.56u
M9 net34 B1 VSS VSS N l=0.18u w=0.56u
.ends OAI2BB2XL
*.SCALE meter
.GLOBAL GND VSS VDD

.subckt OAI31X1 Y A0 A1 A2 B0
M0 VDD A2 hnet11 VDD P l=0.18u w=1.4u
M1 hnet11 A1 hnet14 VDD P l=0.18u w=1.4u
M2 hnet14 A0 Y VDD P l=0.18u w=1.4u
M3 net24 A0 VSS VSS N l=0.18u w=0.8u
M4 Y B0 net24 VSS N l=0.18u w=0.8u
M5 net24 A2 VSS VSS N l=0.18u w=0.8u
M6 net24 A1 VSS VSS N l=0.18u w=0.8u
M7 Y B0 VDD VDD P l=0.18u w=0.9u
.ends OAI31X1
*.SCALE meter
.GLOBAL GND VSS VDD

.subckt OAI31X2 Y A0 A1 A2 B0
M0 VDD A2 hnet11 VDD P l=0.18u w=1.4u
M1 hnet11 A1 hnet12 VDD P l=0.18u w=1.4u
M2 hnet12 A0 Y VDD P l=0.18u w=1.4u
M3 VDD A2 hnet14 VDD P l=0.18u w=1.4u
M4 hnet14 A1 hnet15 VDD P l=0.18u w=1.4u
M5 hnet15 A0 Y VDD P l=0.18u w=1.4u
M6 net24 A0 VSS VSS N l=0.18u w=1.6u
M7 Y B0 net24 VSS N l=0.18u w=1.58u
M8 net24 A2 VSS VSS N l=0.18u w=1.6u
M9 net24 A1 VSS VSS N l=0.18u w=1.6u
M10 Y B0 VDD VDD P l=0.18u w=1.8u
.ends OAI31X2
*.SCALE meter
.GLOBAL GND VSS VDD

.subckt OAI31X4 Y A0 A1 A2 B0
M0 net19 net23 VSS VSS N l=0.18u w=0.96u
M1 VDD net23 net19 VDD P l=0.18u w=1.44u
M2 Y net19 VSS VSS N l=0.18u w=2.4u
M3 VDD net19 Y VDD P l=0.18u w=3.6u
M4 VDD A2 hnet17 VDD P l=0.18u w=0.88u
M5 hnet17 A1 hnet20 VDD P l=0.18u w=0.88u
M6 hnet20 A0 net23 VDD P l=0.18u w=0.88u
M7 net29 A0 VSS VSS N l=0.18u w=0.5u
M8 net23 B0 net29 VSS N l=0.18u w=0.5u
M9 net29 A2 VSS VSS N l=0.18u w=0.5u
M10 net29 A1 VSS VSS N l=0.18u w=0.5u
M11 net23 B0 VDD VDD P l=0.18u w=0.58u
.ends OAI31X4
*.SCALE meter
.GLOBAL GND VSS VDD

.subckt OAI31XL Y A0 A1 A2 B0
M0 VDD A2 hnet11 VDD P l=0.18u w=0.98u
M1 hnet11 A1 hnet14 VDD P l=0.18u w=0.98u
M2 hnet14 A0 Y VDD P l=0.18u w=0.98u
M3 net24 A0 VSS VSS N l=0.18u w=0.56u
M4 Y B0 net24 VSS N l=0.18u w=0.56u
M5 net24 A2 VSS VSS N l=0.18u w=0.56u
M6 net24 A1 VSS VSS N l=0.18u w=0.56u
M7 Y B0 VDD VDD P l=0.18u w=0.64u
.ends OAI31XL
*.SCALE meter
.GLOBAL GND VSS VDD

.subckt OAI32X1 Y A0 A1 A2 B0 B1
M0 VDD A2 hnet11 VDD P l=0.18u w=1.4u
M1 hnet11 A1 hnet14 VDD P l=0.18u w=1.4u
M2 hnet14 A0 Y VDD P l=0.18u w=1.4u
M3 VDD B1 hnet21 VDD P l=0.18u w=1.2u
M4 hnet21 B0 Y VDD P l=0.18u w=1.2u
M5 net46 A0 VSS VSS N l=0.18u w=0.8u
M6 Y B0 net46 VSS N l=0.18u w=0.8u
M7 Y B1 net46 VSS N l=0.18u w=0.8u
M8 net46 A1 VSS VSS N l=0.18u w=0.8u
M9 net46 A2 VSS VSS N l=0.18u w=0.8u
.ends OAI32X1
*.SCALE meter
.GLOBAL GND VSS VDD

.subckt OAI32X2 Y A0 A1 A2 B0 B1
M0 VDD A2 hnet11 VDD P l=0.18u w=1.4u
M1 hnet11 A1 hnet12 VDD P l=0.18u w=1.4u
M2 hnet12 A0 Y VDD P l=0.18u w=1.4u
M3 VDD A2 hnet14 VDD P l=0.18u w=1.4u
M4 hnet14 A1 hnet15 VDD P l=0.18u w=1.4u
M5 hnet15 A0 Y VDD P l=0.18u w=1.4u
M6 VDD B1 hnet24 VDD P l=0.18u w=1.2u
M7 hnet24 B0 Y VDD P l=0.18u w=1.2u
M8 VDD B1 hnet21 VDD P l=0.18u w=1.2u
M9 hnet21 B0 Y VDD P l=0.18u w=1.2u
M10 net46 A0 VSS VSS N l=0.19u w=1.44u
M11 Y B0 net46 VSS N l=0.19u w=1.44u
M12 Y B1 net46 VSS N l=0.19u w=1.44u
M13 net46 A1 VSS VSS N l=0.19u w=1.44u
M14 net46 A2 VSS VSS N l=0.19u w=1.44u
.ends OAI32X2
*.SCALE meter
.GLOBAL GND VSS VDD

.subckt OAI32X4 Y A0 A1 A2 B0 B1
M0 net22 net26 VSS VSS N l=0.18u w=0.94u
M1 VDD net26 net22 VDD P l=0.18u w=1.44u
M2 Y net22 VSS VSS N l=0.18u w=2.4u
M3 VDD net22 Y VDD P l=0.18u w=3.6u
M4 VDD A2 hnet19 VDD P l=0.18u w=0.88u
M5 hnet19 A1 hnet22 VDD P l=0.18u w=0.88u
M6 hnet22 A0 net26 VDD P l=0.18u w=0.88u
M7 VDD B1 hnet28 VDD P l=0.18u w=0.76u
M8 hnet28 B0 net26 VDD P l=0.18u w=0.76u
M9 net47 A0 VSS VSS N l=0.18u w=0.5u
M10 net26 B0 net47 VSS N l=0.18u w=0.5u
M11 net26 B1 net47 VSS N l=0.18u w=0.5u
M12 net47 A1 VSS VSS N l=0.18u w=0.5u
M13 net47 A2 VSS VSS N l=0.18u w=0.5u
.ends OAI32X4
*.SCALE meter
.GLOBAL GND VSS VDD

.subckt OAI32XL Y A0 A1 A2 B0 B1
M0 VDD A2 hnet11 VDD P l=0.18u w=0.98u
M1 hnet11 A1 hnet14 VDD P l=0.18u w=0.98u
M2 hnet14 A0 Y VDD P l=0.18u w=0.98u
M3 VDD B1 hnet21 VDD P l=0.18u w=0.84u
M4 hnet21 B0 Y VDD P l=0.18u w=0.84u
M5 net46 A0 VSS VSS N l=0.18u w=0.56u
M6 Y B0 net46 VSS N l=0.18u w=0.56u
M7 Y B1 net46 VSS N l=0.18u w=0.56u
M8 net46 A1 VSS VSS N l=0.18u w=0.56u
M9 net46 A2 VSS VSS N l=0.18u w=0.56u
.ends OAI32XL
*.SCALE meter
.GLOBAL GND VSS VDD

.subckt OAI33X1 Y A0 A1 A2 B0 B1 B2
M0 VDD A2 hnet12 VDD P l=0.18u w=1.4u
M1 hnet12 A1 hnet15 VDD P l=0.18u w=1.4u
M2 hnet15 A0 Y VDD P l=0.18u w=1.4u
M3 VDD B2 hnet19 VDD P l=0.18u w=1.4u
M4 hnet19 B1 hnet22 VDD P l=0.18u w=1.4u
M5 hnet22 B0 Y VDD P l=0.18u w=1.4u
M6 net56 B0 VSS VSS N l=0.18u w=0.8u
M7 Y A0 net56 VSS N l=0.18u w=0.8u
M8 Y A1 net56 VSS N l=0.18u w=0.8u
M9 Y A2 net56 VSS N l=0.18u w=0.8u
M10 net56 B1 VSS VSS N l=0.18u w=0.8u
M11 net56 B2 VSS VSS N l=0.18u w=0.8u
.ends OAI33X1
*.SCALE meter
.GLOBAL GND VSS VDD

.subckt OAI33X2 Y A0 A1 A2 B0 B1 B2
M0 VDD A2 hnet12 VDD P l=0.18u w=1.4u
M1 hnet12 A1 hnet13 VDD P l=0.18u w=1.4u
M2 hnet13 A0 Y VDD P l=0.18u w=1.4u
M3 VDD A2 hnet15 VDD P l=0.18u w=1.4u
M4 hnet15 A1 hnet16 VDD P l=0.18u w=1.4u
M5 hnet16 A0 Y VDD P l=0.18u w=1.4u
M6 VDD B2 hnet21 VDD P l=0.18u w=1.4u
M7 hnet21 B1 hnet22 VDD P l=0.18u w=1.4u
M8 hnet22 B0 Y VDD P l=0.18u w=1.4u
M9 VDD B2 hnet24 VDD P l=0.18u w=1.4u
M10 hnet24 B1 hnet25 VDD P l=0.18u w=1.4u
M11 hnet25 B0 Y VDD P l=0.18u w=1.4u
M12 net56 B0 VSS VSS N l=0.19u w=1.44u
M13 Y A0 net56 VSS N l=0.19u w=1.44u
M14 Y A1 net56 VSS N l=0.19u w=1.44u
M15 Y A2 net56 VSS N l=0.19u w=1.44u
M16 net56 B1 VSS VSS N l=0.19u w=1.44u
M17 net56 B2 VSS VSS N l=0.19u w=1.44u
.ends OAI33X2
*.SCALE meter
.GLOBAL GND VSS VDD

.subckt OAI33X4 Y A0 A1 A2 B0 B1 B2
M0 net32 net40 VSS VSS N l=0.18u w=0.96u
M1 VDD net40 net32 VDD P l=0.18u w=1.44u
M2 Y net32 VSS VSS N l=0.18u w=2.4u
M3 VDD net32 Y VDD P l=0.18u w=3.6u
M4 VDD A2 hnet20 VDD P l=0.18u w=0.88u
M5 hnet20 A1 hnet23 VDD P l=0.18u w=0.88u
M6 hnet23 A0 net40 VDD P l=0.18u w=0.88u
M7 VDD B2 hnet26 VDD P l=0.18u w=0.88u
M8 hnet26 B1 hnet29 VDD P l=0.18u w=0.88u
M9 hnet29 B0 net40 VDD P l=0.18u w=0.88u
M10 net61 B0 VSS VSS N l=0.18u w=0.5u
M11 net40 A0 net61 VSS N l=0.18u w=0.5u
M12 net40 A1 net61 VSS N l=0.18u w=0.5u
M13 net40 A2 net61 VSS N l=0.18u w=0.5u
M14 net61 B1 VSS VSS N l=0.18u w=0.5u
M15 net61 B2 VSS VSS N l=0.18u w=0.5u
.ends OAI33X4
*.SCALE meter
.GLOBAL GND VSS VDD

.subckt OAI33XL Y A0 A1 A2 B0 B1 B2
M0 VDD A2 hnet12 VDD P l=0.18u w=0.98u
M1 hnet12 A1 hnet15 VDD P l=0.18u w=0.98u
M2 hnet15 A0 Y VDD P l=0.18u w=0.98u
M3 VDD B2 hnet19 VDD P l=0.18u w=0.98u
M4 hnet19 B1 hnet22 VDD P l=0.18u w=0.98u
M5 hnet22 B0 Y VDD P l=0.18u w=0.98u
M6 net56 B0 VSS VSS N l=0.18u w=0.56u
M7 Y A0 net56 VSS N l=0.18u w=0.56u
M8 Y A1 net56 VSS N l=0.18u w=0.56u
M9 Y A2 net56 VSS N l=0.18u w=0.56u
M10 net56 B1 VSS VSS N l=0.18u w=0.56u
M11 net56 B2 VSS VSS N l=0.18u w=0.56u
.ends OAI33XL
*.SCALE meter
.GLOBAL GND VSS VDD

.subckt OR2X1 Y A B
M0 Y net9 VSS VSS N l=0.18u w=0.6u
M1 VDD net9 Y VDD P l=0.18u w=0.9u
M2 VDD B hnet12 VDD P l=0.18u w=0.56u
M3 hnet12 A net9 VDD P l=0.18u w=0.56u
M4 net9 B VSS VSS N l=0.18u w=0.3u
M5 net9 A VSS VSS N l=0.18u w=0.3u
.ends OR2X1
*.SCALE meter
.GLOBAL GND VSS VDD

.subckt OR2X2 Y A B
M0 Y net9 VSS VSS N l=0.18u w=1.2u
M1 VDD net9 Y VDD P l=0.18u w=1.7u
M2 VDD B hnet12 VDD P l=0.18u w=0.96u
M3 hnet12 A net9 VDD P l=0.18u w=0.96u
M4 net9 B VSS VSS N l=0.18u w=0.48u
M5 net9 A VSS VSS N l=0.18u w=0.48u
.ends OR2X2
*.SCALE meter
.GLOBAL GND VSS VDD

.subckt OR2X4 Y A B
M0 Y net9 VSS VSS N l=0.18u w=2.4u
M1 VDD net9 Y VDD P l=0.18u w=3.6u
M2 VDD B hnet12 VDD P l=0.18u w=1.7u
M3 hnet12 A net9 VDD P l=0.18u w=1.7u
M4 net9 B VSS VSS N l=0.18u w=0.94u
M5 net9 A VSS VSS N l=0.18u w=0.94u
.ends OR2X4
*.SCALE meter
.GLOBAL GND VSS VDD

.subckt OR2XL Y A B
M0 Y net9 VSS VSS N l=0.18u w=0.42u
M1 VDD net9 Y VDD P l=0.18u w=0.64u
M2 VDD B hnet12 VDD P l=0.18u w=0.56u
M3 hnet12 A net9 VDD P l=0.18u w=0.56u
M4 net9 B VSS VSS N l=0.18u w=0.3u
M5 net9 A VSS VSS N l=0.18u w=0.3u
.ends OR2XL
*.SCALE meter
.GLOBAL GND VSS VDD

.subckt OR3X1 Y A B C
M0 Y net11 VSS VSS N l=0.18u w=0.6u
M1 VDD net11 Y VDD P l=0.18u w=0.9u
M2 VDD C hnet17 VDD P l=0.18u w=0.66u
M3 hnet17 B hnet16 VDD P l=0.18u w=0.66u
M4 hnet16 A net11 VDD P l=0.18u w=0.66u
M5 net11 C VSS VSS N l=0.18u w=0.3u
M6 net11 B VSS VSS N l=0.18u w=0.3u
M7 net11 A VSS VSS N l=0.18u w=0.3u
.ends OR3X1
*.SCALE meter
.GLOBAL GND VSS VDD

.subckt OR3X2 Y A B C
M0 Y net11 VSS VSS N l=0.18u w=1.2u
M1 VDD net11 Y VDD P l=0.18u w=1.74u
M2 VDD C hnet17 VDD P l=0.18u w=1.12u
M3 hnet17 B hnet16 VDD P l=0.18u w=1.12u
M4 hnet16 A net11 VDD P l=0.18u w=1.12u
M5 net11 C VSS VSS N l=0.18u w=0.48u
M6 net11 B VSS VSS N l=0.18u w=0.48u
M7 net11 A VSS VSS N l=0.18u w=0.48u
.ends OR3X2
*.SCALE meter
.GLOBAL GND VSS VDD

.subckt OR3X4 Y A B C
M0 Y net11 VSS VSS N l=0.18u w=2.4u
M1 VDD net11 Y VDD P l=0.18u w=3.54u
M2 VDD C hnet19 VDD P l=0.18u w=1.12u
M3 hnet19 B hnet15 VDD P l=0.18u w=1.12u
M4 hnet15 A net11 VDD P l=0.18u w=1.12u
M5 VDD C hnet14 VDD P l=0.18u w=1.12u
M6 hnet14 B hnet12 VDD P l=0.18u w=1.12u
M7 hnet12 A net11 VDD P l=0.18u w=1.12u
M8 net11 C VSS VSS N l=0.18u w=0.96u
M9 net11 B VSS VSS N l=0.18u w=0.96u
M10 net11 A VSS VSS N l=0.18u w=0.96u
.ends OR3X4
*.SCALE meter
.GLOBAL GND VSS VDD

.subckt OR3XL Y A B C
M0 Y net11 VSS VSS N l=0.18u w=0.42u
M1 VDD net11 Y VDD P l=0.18u w=0.64u
M2 VDD C hnet17 VDD P l=0.18u w=0.66u
M3 hnet17 B hnet16 VDD P l=0.18u w=0.66u
M4 hnet16 A net11 VDD P l=0.18u w=0.66u
M5 net11 C VSS VSS N l=0.18u w=0.3u
M6 net11 B VSS VSS N l=0.18u w=0.3u
M7 net11 A VSS VSS N l=0.18u w=0.3u
.ends OR3XL
*.SCALE meter
.GLOBAL GND VSS VDD

.subckt OR4X1 Y A B C D
M0 Y net15 VSS VSS N l=0.18u w=0.6u
M1 VDD net15 Y VDD P l=0.18u w=0.9u
M2 VDD D hnet15 VDD P l=0.18u w=0.76u
M3 hnet15 C hnet19 VDD P l=0.18u w=0.76u
M4 hnet19 B hnet14 VDD P l=0.18u w=0.76u
M5 hnet14 A net15 VDD P l=0.18u w=0.76u
M6 net15 D VSS VSS N l=0.18u w=0.3u
M7 net15 C VSS VSS N l=0.18u w=0.3u
M8 net15 B VSS VSS N l=0.18u w=0.3u
M9 net15 A VSS VSS N l=0.18u w=0.3u
.ends OR4X1
*.SCALE meter
.GLOBAL GND VSS VDD

.subckt OR4X2 Y A B C D
M0 Y net15 VSS VSS N l=0.18u w=1.2u
M1 VDD net15 Y VDD P l=0.18u w=1.74u
M2 VDD D hnet15 VDD P l=0.18u w=1.32u
M3 hnet15 C hnet19 VDD P l=0.18u w=1.32u
M4 hnet19 B hnet14 VDD P l=0.18u w=1.32u
M5 hnet14 A net15 VDD P l=0.18u w=1.32u
M6 net15 D VSS VSS N l=0.18u w=0.48u
M7 net15 C VSS VSS N l=0.18u w=0.48u
M8 net15 B VSS VSS N l=0.18u w=0.48u
M9 net15 A VSS VSS N l=0.18u w=0.48u
.ends OR4X2
*.SCALE meter
.GLOBAL GND VSS VDD

.subckt OR4X4 Y A B C D
M0 Y net15 VSS VSS N l=0.19u w=2.54u
M1 VDD net15 Y VDD P l=0.18u w=3.48u
M2 VDD D hnet18 VDD P l=0.18u w=1.32u
M3 hnet18 C hnet17 VDD P l=0.18u w=1.32u
M4 hnet17 B hnet16 VDD P l=0.18u w=1.32u
M5 hnet16 A net15 VDD P l=0.18u w=1.32u
M6 VDD D hnet14 VDD P l=0.18u w=1.32u
M7 hnet14 C hnet13 VDD P l=0.18u w=1.32u
M8 hnet13 B hnet21 VDD P l=0.18u w=1.32u
M9 hnet21 A net15 VDD P l=0.18u w=1.32u
M10 net15 D VSS VSS N l=0.18u w=0.96u
M11 net15 C VSS VSS N l=0.18u w=0.96u
M12 net15 B VSS VSS N l=0.18u w=0.96u
M13 net15 A VSS VSS N l=0.18u w=0.96u
.ends OR4X4
*.SCALE meter
.GLOBAL GND VSS VDD

.subckt OR4XL Y A B C D
M0 Y net15 VSS VSS N l=0.18u w=0.42u
M1 VDD net15 Y VDD P l=0.18u w=0.64u
M2 VDD D hnet15 VDD P l=0.18u w=0.76u
M3 hnet15 C hnet19 VDD P l=0.18u w=0.76u
M4 hnet19 B hnet14 VDD P l=0.18u w=0.76u
M5 hnet14 A net15 VDD P l=0.18u w=0.76u
M6 net15 D VSS VSS N l=0.18u w=0.3u
M7 net15 C VSS VSS N l=0.18u w=0.3u
M8 net15 B VSS VSS N l=0.18u w=0.3u
M9 net15 A VSS VSS N l=0.18u w=0.3u
.ends OR4XL
*.SCALE meter
.GLOBAL GND VSS VDD

.subckt RF1R1WX2 RB RW RWN WB WW
M0 hnet14 net29 net18 VDD P l=0.18u w=0.56u
M1 VDD WB hnet14 VDD P l=0.18u w=0.56u
M2 hnet12 WB VSS VSS N l=0.18u w=0.28u
M3 net18 WW hnet12 VSS N l=0.18u w=0.28u
M4 hnet22 WW net18 VDD P l=0.18u w=0.28u
M5 VDD q hnet22 VDD P l=0.18u w=0.28u
M6 hnet20 q VSS VSS N l=0.18u w=0.28u
M7 net18 net29 hnet20 VSS N l=0.18u w=0.28u
M8 hnet30 RWN RB VDD P l=0.18u w=1.77u
M9 VDD q hnet30 VDD P l=0.18u w=1.77u
M10 hnet28 q VSS VSS N l=0.18u w=1.2u
M11 RB RW hnet28 VSS N l=0.18u w=1.2u
M12 net29 WW VSS VSS N l=0.18u w=0.28u
M13 VDD WW net29 VDD P l=0.18u w=0.56u
M14 q net18 VSS VSS N l=0.18u w=0.42u
M15 VDD net18 q VDD P l=0.18u w=0.8u
.ends RF1R1WX2
*.SCALE meter
.GLOBAL GND VSS VDD

.subckt RF2R1WX2 R1B R2B R1W R2W WB WW
M0 hnet17 net28 R2B VDD P l=0.18u w=1.77u
M1 VDD q hnet17 VDD P l=0.18u w=1.77u
M2 hnet15 q VSS VSS N l=0.18u w=1.2u
M3 R2B R2W hnet15 VSS N l=0.18u w=1.2u
M4 hnet25 net48 net33 VDD P l=0.18u w=0.56u
M5 VDD WB hnet25 VDD P l=0.18u w=0.56u
M6 hnet23 WB VSS VSS N l=0.18u w=0.28u
M7 net33 WW hnet23 VSS N l=0.18u w=0.28u
M8 hnet33 WW net33 VDD P l=0.18u w=0.42u
M9 VDD q hnet33 VDD P l=0.18u w=0.42u
M10 hnet31 q VSS VSS N l=0.18u w=0.28u
M11 net33 net48 hnet31 VSS N l=0.18u w=0.28u
M12 hnet41 net40 R1B VDD P l=0.18u w=1.77u
M13 VDD q hnet41 VDD P l=0.18u w=1.77u
M14 hnet39 q VSS VSS N l=0.18u w=1.2u
M15 R1B R1W hnet39 VSS N l=0.18u w=1.2u
M16 net28 R2W VSS VSS N l=0.18u w=0.28u
M17 VDD R2W net28 VDD P l=0.18u w=0.44u
M18 net40 R1W VSS VSS N l=0.18u w=0.28u
M19 VDD R1W net40 VDD P l=0.18u w=0.42u
M20 net48 WW VSS VSS N l=0.18u w=0.28u
M21 VDD WW net48 VDD P l=0.18u w=0.44u
M22 q net33 VSS VSS N l=0.18u w=0.46u
M23 VDD net33 q VDD P l=0.18u w=0.92u
.ends RF2R1WX2
*.SCALE meter
.GLOBAL GND VSS VDD

.subckt RFRDX1 BRB RB
M0 RB BRB VSS VSS N l=1.14u w=0.28u
M1 VDD BRB RB VDD P l=0.57u w=0.28u
M2 BRB RB VSS VSS N l=0.18u w=0.6u
M3 VDD RB BRB VDD P l=0.18u w=0.9u
.ends RFRDX1
*.SCALE meter
.GLOBAL GND VSS VDD

.subckt RFRDX2 BRB RB
M0 RB BRB VSS VSS N l=1.14u w=0.28u
M1 VDD BRB RB VDD P l=0.57u w=0.28u
M2 BRB RB VSS VSS N l=0.18u w=1.2u
M3 VDD RB BRB VDD P l=0.18u w=1.77u
.ends RFRDX2
*.SCALE meter
.GLOBAL GND VSS VDD

.subckt RFRDX4 BRB RB
M0 RB BRB VSS VSS N l=1.11u w=0.28u
M1 VDD BRB RB VDD P l=0.57u w=0.28u
M2 BRB RB VSS VSS N l=0.18u w=2.4u
M3 VDD RB BRB VDD P l=0.18u w=3.54u
.ends RFRDX4
*.SCALE meter
.GLOBAL GND VSS VDD

.subckt RSLATNX1 Q QN RN SN
M0 net17 RN VSS VSS N l=0.18u w=0.3u
M1 VDD RN net17 VDD P l=0.18u w=0.42u
M2 net19 SN VSS VSS N l=0.18u w=0.3u
M3 VDD SN net19 VDD P l=0.18u w=0.42u
M4 QN net29 VSS VSS N l=0.18u w=0.6u
M5 VDD net29 QN VDD P l=0.18u w=0.9u
M6 Q net26 VSS VSS N l=0.18u w=0.6u
M7 VDD net26 Q VDD P l=0.18u w=0.9u
M8 VDD net26 hnet28 VDD P l=0.18u w=0.92u
M9 hnet28 net17 net29 VDD P l=0.18u w=0.92u
M10 net29 net26 VSS VSS N l=0.18u w=0.46u
M11 net29 net17 VSS VSS N l=0.18u w=0.46u
M12 VDD net29 hnet32 VDD P l=0.18u w=0.92u
M13 hnet32 net19 net26 VDD P l=0.18u w=0.92u
M14 net26 net29 VSS VSS N l=0.18u w=0.46u
M15 net26 net19 VSS VSS N l=0.18u w=0.46u
.ends RSLATNX1
*.SCALE meter
.GLOBAL GND VSS VDD

.subckt RSLATNX2 Q QN RN SN
M0 net17 RN VSS VSS N l=0.18u w=0.42u
M1 VDD RN net17 VDD P l=0.18u w=0.64u
M2 net19 SN VSS VSS N l=0.18u w=0.42u
M3 VDD SN net19 VDD P l=0.18u w=0.64u
M4 QN net29 VSS VSS N l=0.18u w=1.2u
M5 VDD net29 QN VDD P l=0.18u w=1.76u
M6 Q net26 VSS VSS N l=0.18u w=1.2u
M7 VDD net26 Q VDD P l=0.18u w=1.76u
M8 VDD net26 hnet28 VDD P l=0.18u w=1.76u
M9 hnet28 net17 net29 VDD P l=0.18u w=1.76u
M10 net29 net26 VSS VSS N l=0.18u w=0.9u
M11 net29 net17 VSS VSS N l=0.18u w=0.9u
M12 VDD net29 hnet32 VDD P l=0.18u w=1.76u
M13 hnet32 net19 net26 VDD P l=0.18u w=1.76u
M14 net26 net29 VSS VSS N l=0.18u w=0.9u
M15 net26 net19 VSS VSS N l=0.18u w=0.9u
.ends RSLATNX2
*.SCALE meter
.GLOBAL GND VSS VDD

.subckt RSLATNX4 Q QN RN SN
M0 VDD net39 hnet17 VDD P l=0.18u w=1.76u
M1 hnet17 net50 net45 VDD P l=0.18u w=1.76u
M2 VDD net39 hnet13 VDD P l=0.18u w=1.76u
M3 hnet13 net50 net45 VDD P l=0.18u w=1.76u
M4 VDD net45 hnet23 VDD P l=0.18u w=1.76u
M5 hnet23 net48 net39 VDD P l=0.18u w=1.76u
M6 VDD net45 hnet19 VDD P l=0.18u w=1.76u
M7 hnet19 net48 net39 VDD P l=0.18u w=1.76u
M8 net45 net50 VSS VSS N l=0.19u w=1.86u
M9 net45 net39 VSS VSS N l=0.19u w=1.86u
M10 net39 net48 VSS VSS N l=0.19u w=1.86u
M11 net39 net45 VSS VSS N l=0.19u w=1.86u
M12 net48 RN VSS VSS N l=0.18u w=0.86u
M13 VDD RN net48 VDD P l=0.18u w=1.28u
M14 net50 SN VSS VSS N l=0.18u w=0.86u
M15 VDD SN net50 VDD P l=0.18u w=1.28u
M16 QN net39 VSS VSS N l=0.18u w=2.4u
M17 VDD net39 QN VDD P l=0.18u w=3.52u
M18 Q net45 VSS VSS N l=0.18u w=2.4u
M19 VDD net45 Q VDD P l=0.18u w=3.52u
.ends RSLATNX4
*.SCALE meter
.GLOBAL GND VSS VDD

.subckt RSLATNXL Q QN RN SN
M0 net17 RN VSS VSS N l=0.18u w=0.3u
M1 VDD RN net17 VDD P l=0.18u w=0.42u
M2 net19 SN VSS VSS N l=0.18u w=0.3u
M3 VDD SN net19 VDD P l=0.18u w=0.42u
M4 QN net29 VSS VSS N l=0.18u w=0.46u
M5 VDD net29 QN VDD P l=0.18u w=0.64u
M6 Q net26 VSS VSS N l=0.18u w=0.46u
M7 VDD net26 Q VDD P l=0.18u w=0.64u
M8 VDD net26 hnet28 VDD P l=0.18u w=0.56u
M9 hnet28 net17 net29 VDD P l=0.18u w=0.56u
M10 net29 net26 VSS VSS N l=0.18u w=0.3u
M11 net29 net17 VSS VSS N l=0.18u w=0.3u
M12 VDD net29 hnet32 VDD P l=0.18u w=0.56u
M13 hnet32 net19 net26 VDD P l=0.18u w=0.56u
M14 net26 net29 VSS VSS N l=0.18u w=0.3u
M15 net26 net19 VSS VSS N l=0.18u w=0.3u
.ends RSLATNXL
*.SCALE meter
.GLOBAL GND VSS VDD

.subckt RSLATX1 Q QN R S
M0 net17 R VSS VSS N l=0.18u w=0.3u
M1 VDD R net17 VDD P l=0.18u w=0.42u
M2 net19 S VSS VSS N l=0.18u w=0.3u
M3 VDD S net19 VDD P l=0.18u w=0.42u
M4 Q net30 VSS VSS N l=0.18u w=0.6u
M5 VDD net30 Q VDD P l=0.18u w=0.9u
M6 QN net27 VSS VSS N l=0.18u w=0.6u
M7 VDD net27 QN VDD P l=0.18u w=0.9u
M8 VDD net27 net30 VDD P l=0.18u w=0.64u
M9 VDD net17 net30 VDD P l=0.18u w=0.64u
M10 hnet30 net27 VSS VSS N l=0.18u w=0.56u
M11 net30 net17 hnet30 VSS N l=0.18u w=0.56u
M12 VDD net30 net27 VDD P l=0.18u w=0.64u
M13 VDD net19 net27 VDD P l=0.18u w=0.64u
M14 hnet34 net30 VSS VSS N l=0.18u w=0.56u
M15 net27 net19 hnet34 VSS N l=0.18u w=0.56u
.ends RSLATX1
*.SCALE meter
.GLOBAL GND VSS VDD

.subckt RSLATX2 Q QN R S
M0 net17 R VSS VSS N l=0.18u w=0.38u
M1 VDD R net17 VDD P l=0.18u w=0.56u
M2 net19 S VSS VSS N l=0.18u w=0.38u
M3 VDD S net19 VDD P l=0.18u w=0.56u
M4 Q net30 VSS VSS N l=0.18u w=1.2u
M5 VDD net30 Q VDD P l=0.18u w=1.76u
M6 QN net27 VSS VSS N l=0.18u w=1.2u
M7 VDD net27 QN VDD P l=0.18u w=1.76u
M8 VDD net27 net30 VDD P l=0.18u w=1.3u
M9 VDD net17 net30 VDD P l=0.18u w=1.3u
M10 hnet30 net27 VSS VSS N l=0.18u w=1.14u
M11 net30 net17 hnet30 VSS N l=0.18u w=1.14u
M12 VDD net30 net27 VDD P l=0.18u w=1.3u
M13 VDD net19 net27 VDD P l=0.18u w=1.3u
M14 hnet34 net30 VSS VSS N l=0.18u w=1.14u
M15 net27 net19 hnet34 VSS N l=0.18u w=1.14u
.ends RSLATX2
*.SCALE meter
.GLOBAL GND VSS VDD

.subckt RSLATX4 Q QN R S
M0 net17 R VSS VSS N l=0.18u w=0.78u
M1 VDD R net17 VDD P l=0.18u w=1.16u
M2 net19 S VSS VSS N l=0.18u w=0.78u
M3 VDD S net19 VDD P l=0.18u w=1.16u
M4 Q net30 VSS VSS N l=0.18u w=2.4u
M5 VDD net30 Q VDD P l=0.18u w=3.6u
M6 QN net27 VSS VSS N l=0.18u w=2.4u
M7 VDD net27 QN VDD P l=0.18u w=3.6u
M8 VDD net27 net30 VDD P l=0.18u w=2.6u
M9 VDD net17 net30 VDD P l=0.18u w=2.6u
M10 hnet31 net27 VSS VSS N l=0.18u w=1.14u
M11 net30 net17 hnet31 VSS N l=0.18u w=1.14u
M12 hnet27 net27 VSS VSS N l=0.18u w=1.14u
M13 net30 net17 hnet27 VSS N l=0.18u w=1.14u
M14 VDD net30 net27 VDD P l=0.18u w=2.6u
M15 VDD net19 net27 VDD P l=0.18u w=2.6u
M16 hnet36 net30 VSS VSS N l=0.18u w=1.14u
M17 net27 net19 hnet36 VSS N l=0.18u w=1.14u
M18 hnet32 net30 VSS VSS N l=0.18u w=1.14u
M19 net27 net19 hnet32 VSS N l=0.18u w=1.14u
.ends RSLATX4
*.SCALE meter
.GLOBAL GND VSS VDD

.subckt RSLATXL Q QN R S
M0 net17 R VSS VSS N l=0.18u w=0.3u
M1 VDD R net17 VDD P l=0.18u w=0.42u
M2 net19 S VSS VSS N l=0.18u w=0.3u
M3 VDD S net19 VDD P l=0.18u w=0.42u
M4 Q net30 VSS VSS N l=0.18u w=0.42u
M5 VDD net30 Q VDD P l=0.18u w=0.64u
M6 QN net27 VSS VSS N l=0.18u w=0.42u
M7 VDD net27 QN VDD P l=0.18u w=0.64u
M8 VDD net27 net30 VDD P l=0.18u w=0.42u
M9 VDD net17 net30 VDD P l=0.18u w=0.42u
M10 hnet30 net27 VSS VSS N l=0.18u w=0.36u
M11 net30 net17 hnet30 VSS N l=0.18u w=0.36u
M12 VDD net30 net27 VDD P l=0.18u w=0.42u
M13 VDD net19 net27 VDD P l=0.18u w=0.42u
M14 hnet34 net30 VSS VSS N l=0.18u w=0.36u
M15 net27 net19 hnet34 VSS N l=0.18u w=0.36u
.ends RSLATXL
*.SCALE meter
.GLOBAL GND VSS VDD

.subckt SDFFHQX1 Q CK D SE SI
M0 net90 c net97 VSS N l=0.18u w=0.7u
M1 net61 SE net70 VSS N l=0.18u w=0.3u
M2 net61 D net64 VSS N l=0.18u w=0.3u
M3 net64 net103 VSS VSS N l=0.18u w=0.3u
M4 pm cn net61 VSS N l=0.18u w=0.3u
M5 net70 SI VSS VSS N l=0.18u w=0.3u
M6 net90 cn net97 VDD P l=0.18u w=1.04u
M7 net76 D net79 VDD P l=0.18u w=0.3u
M8 net79 SE VDD VDD P l=0.18u w=0.3u
M9 net76 net103 net81 VDD P l=0.18u w=0.42u
M10 pm c net76 VDD P l=0.18u w=0.3u
M11 net81 SI VDD VDD P l=0.18u w=0.42u
M12 hnet27 c net90 VDD P l=0.18u w=0.3u
M13 VDD s hnet27 VDD P l=0.18u w=0.3u
M14 hnet25 s VSS VSS N l=0.18u w=0.3u
M15 net90 cn hnet25 VSS N l=0.18u w=0.3u
M16 hnet33 cn pm VDD P l=0.18u w=0.42u
M17 VDD m hnet33 VDD P l=0.18u w=0.42u
M18 hnet31 m VSS VSS N l=0.18u w=0.3u
M19 pm c hnet31 VSS N l=0.18u w=0.3u
M20 net97 m VSS VSS N l=0.18u w=0.7u
M21 VDD m net97 VDD P l=0.18u w=1.04u
M22 s net90 VSS VSS N l=0.18u w=0.3u
M23 VDD net90 s VDD P l=0.18u w=0.42u
M24 m pm VSS VSS N l=0.18u w=0.3u
M25 VDD pm m VDD P l=0.18u w=0.42u
M26 net103 SE VSS VSS N l=0.18u w=0.3u
M27 VDD SE net103 VDD P l=0.18u w=0.42u
M28 c cn VSS VSS N l=0.18u w=0.3u
M29 VDD cn c VDD P l=0.18u w=0.42u
M30 cn CK VSS VSS N l=0.18u w=0.44u
M31 VDD CK cn VDD P l=0.18u w=0.66u
M32 Q net90 VSS VSS N l=0.18u w=0.57u
M33 VDD net90 Q VDD P l=0.18u w=0.9u
.ends SDFFHQX1
*.SCALE meter
.GLOBAL GND VSS VDD

.subckt SDFFHQX2 Q CK D SE SI
M0 net90 c net97 VSS N l=0.18u w=1.18u
M1 net61 SE net70 VSS N l=0.18u w=0.3u
M2 net61 D net64 VSS N l=0.18u w=0.3u
M3 net64 net103 VSS VSS N l=0.18u w=0.3u
M4 pm cn net61 VSS N l=0.18u w=0.3u
M5 net70 SI VSS VSS N l=0.18u w=0.3u
M6 net90 cn net97 VDD P l=0.18u w=1.76u
M7 net76 D net79 VDD P l=0.18u w=0.36u
M8 net79 SE VDD VDD P l=0.18u w=0.36u
M9 net76 net103 net81 VDD P l=0.18u w=0.42u
M10 pm c net76 VDD P l=0.18u w=0.36u
M11 net81 SI VDD VDD P l=0.18u w=0.42u
M12 hnet27 c net90 VDD P l=0.18u w=0.3u
M13 VDD s hnet27 VDD P l=0.18u w=0.3u
M14 hnet25 s VSS VSS N l=0.18u w=0.3u
M15 net90 cn hnet25 VSS N l=0.18u w=0.3u
M16 hnet33 cn pm VDD P l=0.18u w=0.42u
M17 VDD m hnet33 VDD P l=0.18u w=0.42u
M18 hnet31 m VSS VSS N l=0.18u w=0.3u
M19 pm c hnet31 VSS N l=0.18u w=0.3u
M20 net97 m VSS VSS N l=0.18u w=1.18u
M21 VDD m net97 VDD P l=0.18u w=1.76u
M22 s net90 VSS VSS N l=0.18u w=0.3u
M23 VDD net90 s VDD P l=0.18u w=0.42u
M24 m pm VSS VSS N l=0.18u w=0.4u
M25 VDD pm m VDD P l=0.18u w=0.6u
M26 net103 SE VSS VSS N l=0.18u w=0.3u
M27 VDD SE net103 VDD P l=0.18u w=0.42u
M28 c cn VSS VSS N l=0.18u w=0.34u
M29 VDD cn c VDD P l=0.18u w=0.52u
M30 cn CK VSS VSS N l=0.18u w=0.52u
M31 VDD CK cn VDD P l=0.18u w=0.88u
M32 Q net90 VSS VSS N l=0.18u w=1.14u
M33 VDD net90 Q VDD P l=0.18u w=1.8u
.ends SDFFHQX2
*.SCALE meter
.GLOBAL GND VSS VDD

.subckt SDFFHQX4 Q CK D SE SI
M0 net90 c net97 VSS N l=0.18u w=1.9u
M1 net61 SE net70 VSS N l=0.18u w=0.3u
M2 net61 D net64 VSS N l=0.18u w=0.42u
M3 net64 net101 VSS VSS N l=0.18u w=0.42u
M4 pm cn net61 VSS N l=0.18u w=0.42u
M5 net70 SI VSS VSS N l=0.18u w=0.3u
M6 net90 cn net97 VDD P l=0.18u w=2.88u
M7 net76 D net75 VDD P l=0.18u w=0.62u
M8 net75 SE VDD VDD P l=0.18u w=0.62u
M9 net76 net101 net81 VDD P l=0.18u w=0.42u
M10 pm c net76 VDD P l=0.18u w=0.62u
M11 net81 SI VDD VDD P l=0.18u w=0.42u
M12 hnet27 c net90 VDD P l=0.18u w=0.3u
M13 VDD s hnet27 VDD P l=0.18u w=0.3u
M14 hnet25 s VSS VSS N l=0.18u w=0.3u
M15 net90 cn hnet25 VSS N l=0.18u w=0.3u
M16 hnet33 cn pm VDD P l=0.18u w=0.42u
M17 VDD m hnet33 VDD P l=0.18u w=0.42u
M18 hnet31 m VSS VSS N l=0.18u w=0.3u
M19 pm c hnet31 VSS N l=0.18u w=0.3u
M20 net97 m VSS VSS N l=0.18u w=1.9u
M21 VDD m net97 VDD P l=0.18u w=2.88u
M22 m pm VSS VSS N l=0.18u w=0.66u
M23 VDD pm m VDD P l=0.18u w=1u
M24 net101 SE VSS VSS N l=0.18u w=0.3u
M25 VDD SE net101 VDD P l=0.18u w=0.42u
M26 s net90 VSS VSS N l=0.18u w=0.3u
M27 VDD net90 s VDD P l=0.18u w=0.42u
M28 c cn VSS VSS N l=0.18u w=0.52u
M29 VDD cn c VDD P l=0.18u w=0.78u
M30 cn CK VSS VSS N l=0.18u w=0.88u
M31 VDD CK cn VDD P l=0.18u w=1.32u
M32 Q net90 VSS VSS N l=0.18u w=2.4u
M33 VDD net90 Q VDD P l=0.18u w=3.6u
.ends SDFFHQX4
*.SCALE meter
.GLOBAL GND VSS VDD

.subckt SDFFHQXL Q CK D SE SI
M0 net90 c net97 VSS N l=0.18u w=0.56u
M1 net61 SE net70 VSS N l=0.18u w=0.3u
M2 net61 D net64 VSS N l=0.18u w=0.44u
M3 net64 net103 VSS VSS N l=0.18u w=0.44u
M4 pm cn net61 VSS N l=0.18u w=0.44u
M5 net70 SI VSS VSS N l=0.18u w=0.3u
M6 net90 cn net97 VDD P l=0.18u w=0.84u
M7 net76 D net79 VDD P l=0.18u w=0.54u
M8 net79 SE VDD VDD P l=0.18u w=0.54u
M9 net76 net103 net81 VDD P l=0.18u w=0.42u
M10 pm c net76 VDD P l=0.18u w=0.66u
M11 net81 SI VDD VDD P l=0.18u w=0.42u
M12 hnet27 c net90 VDD P l=0.18u w=0.3u
M13 VDD s hnet27 VDD P l=0.18u w=0.3u
M14 hnet25 s VSS VSS N l=0.18u w=0.3u
M15 net90 cn hnet25 VSS N l=0.18u w=0.3u
M16 hnet33 cn pm VDD P l=0.18u w=0.42u
M17 VDD m hnet33 VDD P l=0.18u w=0.42u
M18 hnet31 m VSS VSS N l=0.18u w=0.3u
M19 pm c hnet31 VSS N l=0.18u w=0.3u
M20 net97 m VSS VSS N l=0.18u w=0.28u
M21 VDD m net97 VDD P l=0.18u w=0.46u
M22 s net90 VSS VSS N l=0.18u w=0.3u
M23 VDD net90 s VDD P l=0.18u w=0.42u
M24 m pm VSS VSS N l=0.18u w=0.3u
M25 VDD pm m VDD P l=0.18u w=0.42u
M26 net103 SE VSS VSS N l=0.18u w=0.3u
M27 VDD SE net103 VDD P l=0.18u w=0.42u
M28 c cn VSS VSS N l=0.18u w=0.3u
M29 VDD cn c VDD P l=0.18u w=0.42u
M30 cn CK VSS VSS N l=0.18u w=0.3u
M31 VDD CK cn VDD P l=0.18u w=0.46u
M32 Q net90 VSS VSS N l=0.18u w=0.42u
M33 VDD net90 Q VDD P l=0.18u w=0.64u
.ends SDFFHQXL
*.SCALE meter
.GLOBAL GND VSS VDD

.subckt SDFFNRX1 Q QN CKN D RN SE SI
M0 VDD net108 hnet28 VDD P l=0.18u w=0.88u
M1 hnet28 net99 s VDD P l=0.18u w=0.88u
M2 s net108 VSS VSS N l=0.18u w=0.44u
M3 s net99 VSS VSS N l=0.18u w=0.44u
M4 VDD net108 hnet32 VDD P l=0.18u w=0.56u
M5 hnet32 pm m VDD P l=0.18u w=0.56u
M6 m net108 VSS VSS N l=0.18u w=0.3u
M7 m pm VSS VSS N l=0.18u w=0.3u
M8 net69 SE net78 VSS N l=0.18u w=0.3u
M9 net69 D net72 VSS N l=0.18u w=0.3u
M10 net72 net110 VSS VSS N l=0.18u w=0.3u
M11 pm cn net69 VSS N l=0.18u w=0.3u
M12 net78 SI VSS VSS N l=0.18u w=0.3u
M13 net81 D net80 VDD P l=0.18u w=0.32u
M14 net80 SE VDD VDD P l=0.18u w=0.32u
M15 net81 net110 net86 VDD P l=0.18u w=0.42u
M16 pm c net81 VDD P l=0.18u w=0.32u
M17 net86 SI VDD VDD P l=0.18u w=0.42u
M18 hnet38 cn net99 VDD P l=0.18u w=0.64u
M19 VDD m hnet38 VDD P l=0.18u w=0.64u
M20 hnet36 m VSS VSS N l=0.18u w=0.42u
M21 net99 c hnet36 VSS N l=0.18u w=0.42u
M22 hnet44 c net99 VDD P l=0.18u w=0.3u
M23 VDD s hnet44 VDD P l=0.18u w=0.3u
M24 hnet42 s VSS VSS N l=0.18u w=0.3u
M25 net99 cn hnet42 VSS N l=0.18u w=0.3u
M26 hnet50 cn pm VDD P l=0.18u w=0.42u
M27 VDD m hnet50 VDD P l=0.18u w=0.42u
M28 hnet48 m VSS VSS N l=0.18u w=0.3u
M29 pm c hnet48 VSS N l=0.18u w=0.3u
M30 Q net118 VSS VSS N l=0.18u w=0.6u
M31 VDD net118 Q VDD P l=0.18u w=0.9u
M32 net108 RN VSS VSS N l=0.18u w=0.34u
M33 VDD RN net108 VDD P l=0.18u w=0.52u
M34 net110 SE VSS VSS N l=0.18u w=0.3u
M35 VDD SE net110 VDD P l=0.18u w=0.42u
M36 cn c VSS VSS N l=0.18u w=0.3u
M37 VDD c cn VDD P l=0.18u w=0.42u
M38 c CKN VSS VSS N l=0.18u w=0.4u
M39 VDD CKN c VDD P l=0.18u w=0.6u
M40 QN s VSS VSS N l=0.18u w=0.6u
M41 VDD s QN VDD P l=0.18u w=0.9u
M42 net118 s VSS VSS N l=0.18u w=0.3u
M43 VDD s net118 VDD P l=0.18u w=0.42u
.ends SDFFNRX1
*.SCALE meter
.GLOBAL GND VSS VDD

.subckt SDFFNRX2 Q QN CKN D RN SE SI
M0 hnet34 cn net99 VDD P l=0.18u w=0.54u
M1 hnet32 cn net99 VDD P l=0.18u w=0.54u
M2 VDD m hnet34 VDD P l=0.18u w=0.54u
M3 VDD m hnet32 VDD P l=0.18u w=0.54u
M4 hnet28 m VSS VSS N l=0.18u w=0.36u
M5 hnet29 m VSS VSS N l=0.18u w=0.36u
M6 net99 c hnet28 VSS N l=0.18u w=0.36u
M7 net99 c hnet29 VSS N l=0.18u w=0.36u
M8 VDD net108 hnet36 VDD P l=0.18u w=1.52u
M9 hnet36 net99 s VDD P l=0.18u w=1.52u
M10 s net108 VSS VSS N l=0.18u w=0.76u
M11 s net99 VSS VSS N l=0.18u w=0.76u
M12 VDD net108 hnet40 VDD P l=0.18u w=0.56u
M13 hnet40 pm m VDD P l=0.18u w=0.56u
M14 m net108 VSS VSS N l=0.18u w=0.3u
M15 m pm VSS VSS N l=0.18u w=0.3u
M16 net73 SE net82 VSS N l=0.18u w=0.3u
M17 net73 D net76 VSS N l=0.18u w=0.3u
M18 net76 net110 VSS VSS N l=0.18u w=0.3u
M19 pm cn net73 VSS N l=0.18u w=0.3u
M20 net82 SI VSS VSS N l=0.18u w=0.3u
M21 net85 D net84 VDD P l=0.18u w=0.32u
M22 net84 SE VDD VDD P l=0.18u w=0.32u
M23 net85 net110 net90 VDD P l=0.18u w=0.42u
M24 pm c net85 VDD P l=0.18u w=0.32u
M25 net90 SI VDD VDD P l=0.18u w=0.42u
M26 hnet46 c net99 VDD P l=0.18u w=0.3u
M27 VDD s hnet46 VDD P l=0.18u w=0.3u
M28 hnet44 s VSS VSS N l=0.18u w=0.3u
M29 net99 cn hnet44 VSS N l=0.18u w=0.3u
M30 hnet52 cn pm VDD P l=0.18u w=0.42u
M31 VDD m hnet52 VDD P l=0.18u w=0.42u
M32 hnet50 m VSS VSS N l=0.18u w=0.3u
M33 pm c hnet50 VSS N l=0.18u w=0.3u
M34 Q net118 VSS VSS N l=0.18u w=1.08u
M35 VDD net118 Q VDD P l=0.18u w=1.8u
M36 net108 RN VSS VSS N l=0.18u w=0.5u
M37 VDD RN net108 VDD P l=0.18u w=0.76u
M38 net110 SE VSS VSS N l=0.18u w=0.3u
M39 VDD SE net110 VDD P l=0.18u w=0.42u
M40 cn c VSS VSS N l=0.18u w=0.3u
M41 VDD c cn VDD P l=0.18u w=0.44u
M42 c CKN VSS VSS N l=0.18u w=0.42u
M43 VDD CKN c VDD P l=0.18u w=0.64u
M44 QN s VSS VSS N l=0.18u w=1.08u
M45 VDD s QN VDD P l=0.18u w=1.8u
M46 net118 s VSS VSS N l=0.18u w=0.48u
M47 VDD s net118 VDD P l=0.18u w=0.72u
.ends SDFFNRX2
*.SCALE meter
.GLOBAL GND VSS VDD

.subckt SDFFNRX4 Q QN CKN D RN SE SI
M0 hnet34 cn net99 VDD P l=0.18u w=1u
M1 hnet32 cn net99 VDD P l=0.18u w=1u
M2 VDD m hnet34 VDD P l=0.18u w=1u
M3 VDD m hnet32 VDD P l=0.18u w=1u
M4 hnet28 m VSS VSS N l=0.18u w=0.7u
M5 hnet29 m VSS VSS N l=0.18u w=0.7u
M6 net99 c hnet28 VSS N l=0.18u w=0.7u
M7 net99 c hnet29 VSS N l=0.18u w=0.7u
M8 VDD net108 hnet37 VDD P l=0.18u w=1.4u
M9 hnet37 net99 s VDD P l=0.18u w=1.4u
M10 VDD net108 hnet35 VDD P l=0.18u w=1.4u
M11 hnet35 net99 s VDD P l=0.18u w=1.4u
M12 s net108 VSS VSS N l=0.18u w=1.4u
M13 s net99 VSS VSS N l=0.18u w=1.4u
M14 VDD net108 hnet41 VDD P l=0.18u w=0.92u
M15 hnet41 pm m VDD P l=0.18u w=0.92u
M16 m net108 VSS VSS N l=0.18u w=0.46u
M17 m pm VSS VSS N l=0.18u w=0.46u
M18 net73 SE net82 VSS N l=0.18u w=0.3u
M19 net73 D net76 VSS N l=0.18u w=0.34u
M20 net76 net110 VSS VSS N l=0.18u w=0.34u
M21 pm cn net73 VSS N l=0.18u w=0.34u
M22 net82 SI VSS VSS N l=0.18u w=0.3u
M23 net85 D net88 VDD P l=0.18u w=0.52u
M24 net88 SE VDD VDD P l=0.18u w=0.52u
M25 net85 net110 net90 VDD P l=0.18u w=0.42u
M26 pm c net85 VDD P l=0.18u w=0.52u
M27 net90 SI VDD VDD P l=0.18u w=0.42u
M28 hnet47 c net99 VDD P l=0.18u w=0.3u
M29 VDD s hnet47 VDD P l=0.18u w=0.3u
M30 hnet45 s VSS VSS N l=0.18u w=0.3u
M31 net99 cn hnet45 VSS N l=0.18u w=0.3u
M32 hnet53 cn pm VDD P l=0.18u w=0.42u
M33 VDD m hnet53 VDD P l=0.18u w=0.42u
M34 hnet51 m VSS VSS N l=0.18u w=0.3u
M35 pm c hnet51 VSS N l=0.18u w=0.3u
M36 Q net118 VSS VSS N l=0.18u w=2.38u
M37 VDD net118 Q VDD P l=0.18u w=3.52u
M38 net108 RN VSS VSS N l=0.18u w=0.9u
M39 VDD RN net108 VDD P l=0.18u w=1.3u
M40 net110 SE VSS VSS N l=0.18u w=0.3u
M41 VDD SE net110 VDD P l=0.18u w=0.42u
M42 cn c VSS VSS N l=0.18u w=0.44u
M43 VDD c cn VDD P l=0.18u w=0.66u
M44 c CKN VSS VSS N l=0.18u w=0.62u
M45 VDD CKN c VDD P l=0.18u w=0.92u
M46 QN s VSS VSS N l=0.18u w=2.38u
M47 VDD s QN VDD P l=0.18u w=3.52u
M48 net118 s VSS VSS N l=0.19u w=1.01u
M49 VDD s net118 VDD P l=0.18u w=1.44u
.ends SDFFNRX4
*.SCALE meter
.GLOBAL GND VSS VDD

.subckt SDFFNRXL Q QN CKN D RN SE SI
M0 VDD net108 hnet28 VDD P l=0.18u w=0.56u
M1 hnet28 net99 s VDD P l=0.18u w=0.56u
M2 s net108 VSS VSS N l=0.18u w=0.3u
M3 s net99 VSS VSS N l=0.18u w=0.3u
M4 VDD net108 hnet32 VDD P l=0.18u w=0.56u
M5 hnet32 pm m VDD P l=0.18u w=0.56u
M6 m net108 VSS VSS N l=0.18u w=0.3u
M7 m pm VSS VSS N l=0.18u w=0.3u
M8 net69 SE net78 VSS N l=0.18u w=0.3u
M9 net69 D net72 VSS N l=0.18u w=0.44u
M10 net72 net110 VSS VSS N l=0.18u w=0.44u
M11 pm cn net69 VSS N l=0.18u w=0.44u
M12 net78 SI VSS VSS N l=0.18u w=0.3u
M13 net81 D net84 VDD P l=0.18u w=0.66u
M14 net84 SE VDD VDD P l=0.18u w=0.66u
M15 net81 net110 net86 VDD P l=0.18u w=0.42u
M16 pm c net81 VDD P l=0.18u w=0.66u
M17 net86 SI VDD VDD P l=0.18u w=0.42u
M18 hnet38 cn net99 VDD P l=0.18u w=0.84u
M19 VDD m hnet38 VDD P l=0.18u w=0.84u
M20 hnet36 m VSS VSS N l=0.18u w=0.56u
M21 net99 c hnet36 VSS N l=0.18u w=0.56u
M22 hnet44 c net99 VDD P l=0.18u w=0.3u
M23 VDD s hnet44 VDD P l=0.18u w=0.3u
M24 hnet42 s VSS VSS N l=0.18u w=0.3u
M25 net99 cn hnet42 VSS N l=0.18u w=0.3u
M26 hnet50 cn pm VDD P l=0.18u w=0.42u
M27 VDD m hnet50 VDD P l=0.18u w=0.42u
M28 hnet48 m VSS VSS N l=0.18u w=0.3u
M29 pm c hnet48 VSS N l=0.18u w=0.3u
M30 Q net118 VSS VSS N l=0.18u w=0.42u
M31 VDD net118 Q VDD P l=0.18u w=0.64u
M32 net108 RN VSS VSS N l=0.18u w=0.3u
M33 VDD RN net108 VDD P l=0.18u w=0.42u
M34 net110 SE VSS VSS N l=0.18u w=0.3u
M35 VDD SE net110 VDD P l=0.18u w=0.42u
M36 cn c VSS VSS N l=0.18u w=0.3u
M37 VDD c cn VDD P l=0.18u w=0.42u
M38 c CKN VSS VSS N l=0.18u w=0.28u
M39 VDD CKN c VDD P l=0.18u w=0.4u
M40 QN s VSS VSS N l=0.18u w=0.42u
M41 VDD s QN VDD P l=0.18u w=0.64u
M42 net118 s VSS VSS N l=0.18u w=0.3u
M43 VDD s net118 VDD P l=0.18u w=0.42u
.ends SDFFNRXL
*.SCALE meter
.GLOBAL GND VSS VDD

.subckt SDFFNSRX1 Q QN CKN D RN SE SI SN
M0 VDD net145 hnet33 VDD P l=0.18u w=0.88u
M1 hnet33 net136 s VDD P l=0.18u w=0.88u
M2 VDD net145 hnet37 VDD P l=0.18u w=0.4u
M3 hnet37 pm m VDD P l=0.18u w=0.4u
M4 s net145 net85 VSS N l=0.18u w=0.58u
M5 s net136 net85 VSS N l=0.18u w=0.58u
M6 net85 SN VSS VSS N l=0.18u w=0.58u
M7 m net145 net94 VSS N l=0.18u w=0.3u
M8 m pm net94 VSS N l=0.18u w=0.3u
M9 net94 SN VSS VSS N l=0.18u w=0.3u
M10 net100 SE net109 VSS N l=0.18u w=0.3u
M11 net100 D net103 VSS N l=0.18u w=0.3u
M12 net103 net147 VSS VSS N l=0.18u w=0.3u
M13 pm cn net100 VSS N l=0.18u w=0.3u
M14 net109 SI VSS VSS N l=0.18u w=0.3u
M15 s SN VDD VDD P l=0.18u w=0.66u
M16 m SN VDD VDD P l=0.18u w=0.3u
M17 net118 D net121 VDD P l=0.18u w=0.3u
M18 net121 SE VDD VDD P l=0.18u w=0.3u
M19 net118 net147 net123 VDD P l=0.18u w=0.42u
M20 pm c net118 VDD P l=0.18u w=0.3u
M21 net123 SI VDD VDD P l=0.18u w=0.42u
M22 hnet41 cn net136 VDD P l=0.18u w=0.68u
M23 VDD m hnet41 VDD P l=0.18u w=0.68u
M24 hnet39 m VSS VSS N l=0.18u w=0.46u
M25 net136 c hnet39 VSS N l=0.18u w=0.46u
M26 hnet47 c net136 VDD P l=0.18u w=0.3u
M27 VDD s hnet47 VDD P l=0.18u w=0.3u
M28 hnet45 s VSS VSS N l=0.18u w=0.3u
M29 net136 cn hnet45 VSS N l=0.18u w=0.3u
M30 hnet53 cn pm VDD P l=0.18u w=0.46u
M31 VDD m hnet53 VDD P l=0.18u w=0.46u
M32 hnet51 m VSS VSS N l=0.18u w=0.3u
M33 pm c hnet51 VSS N l=0.18u w=0.3u
M34 Q net155 VSS VSS N l=0.18u w=0.6u
M35 VDD net155 Q VDD P l=0.18u w=0.9u
M36 net145 RN VSS VSS N l=0.18u w=0.34u
M37 VDD RN net145 VDD P l=0.18u w=0.52u
M38 net147 SE VSS VSS N l=0.18u w=0.3u
M39 VDD SE net147 VDD P l=0.18u w=0.42u
M40 cn c VSS VSS N l=0.18u w=0.3u
M41 VDD c cn VDD P l=0.18u w=0.46u
M42 c CKN VSS VSS N l=0.18u w=0.4u
M43 VDD CKN c VDD P l=0.18u w=0.6u
M44 QN s VSS VSS N l=0.18u w=0.6u
M45 VDD s QN VDD P l=0.18u w=0.9u
M46 net155 s VSS VSS N l=0.18u w=0.3u
M47 VDD s net155 VDD P l=0.18u w=0.42u
.ends SDFFNSRX1
*.SCALE meter
.GLOBAL GND VSS VDD

.subckt SDFFNSRX2 Q QN CKN D RN SE SI SN
M0 VDD net145 hnet33 VDD P l=0.18u w=1.38u
M1 hnet33 net136 s VDD P l=0.18u w=1.38u
M2 VDD net145 hnet37 VDD P l=0.18u w=0.58u
M3 hnet37 pm m VDD P l=0.18u w=0.58u
M4 s net145 net85 VSS N l=0.18u w=1u
M5 s net136 net85 VSS N l=0.18u w=1u
M6 net85 SN VSS VSS N l=0.18u w=1u
M7 m net145 net94 VSS N l=0.18u w=0.38u
M8 m pm net94 VSS N l=0.18u w=0.38u
M9 net94 SN VSS VSS N l=0.18u w=0.38u
M10 net100 SE net109 VSS N l=0.18u w=0.3u
M11 net100 D net103 VSS N l=0.18u w=0.3u
M12 net103 net147 VSS VSS N l=0.18u w=0.3u
M13 pm cn net100 VSS N l=0.18u w=0.3u
M14 net109 SI VSS VSS N l=0.18u w=0.3u
M15 s SN VDD VDD P l=0.18u w=1.14u
M16 m SN VDD VDD P l=0.18u w=0.44u
M17 net118 D net117 VDD P l=0.18u w=0.36u
M18 net117 SE VDD VDD P l=0.18u w=0.36u
M19 net118 net147 net123 VDD P l=0.18u w=0.42u
M20 pm c net118 VDD P l=0.18u w=0.36u
M21 net123 SI VDD VDD P l=0.18u w=0.42u
M22 hnet41 cn net136 VDD P l=0.18u w=1.18u
M23 VDD m hnet41 VDD P l=0.18u w=1.18u
M24 hnet39 m VSS VSS N l=0.18u w=0.8u
M25 net136 c hnet39 VSS N l=0.18u w=0.8u
M26 hnet47 c net136 VDD P l=0.18u w=0.3u
M27 VDD s hnet47 VDD P l=0.18u w=0.3u
M28 hnet45 s VSS VSS N l=0.18u w=0.3u
M29 net136 cn hnet45 VSS N l=0.18u w=0.3u
M30 hnet53 cn pm VDD P l=0.18u w=0.46u
M31 VDD m hnet53 VDD P l=0.18u w=0.46u
M32 hnet51 m VSS VSS N l=0.18u w=0.3u
M33 pm c hnet51 VSS N l=0.18u w=0.3u
M34 Q net155 VSS VSS N l=0.18u w=1.2u
M35 VDD net155 Q VDD P l=0.18u w=1.8u
M36 net145 RN VSS VSS N l=0.18u w=0.56u
M37 VDD RN net145 VDD P l=0.18u w=0.84u
M38 net147 SE VSS VSS N l=0.18u w=0.3u
M39 VDD SE net147 VDD P l=0.18u w=0.42u
M40 cn c VSS VSS N l=0.18u w=0.3u
M41 VDD c cn VDD P l=0.18u w=0.46u
M42 c CKN VSS VSS N l=0.18u w=0.42u
M43 VDD CKN c VDD P l=0.18u w=0.64u
M44 QN s VSS VSS N l=0.18u w=1.2u
M45 VDD s QN VDD P l=0.18u w=1.8u
M46 net155 s VSS VSS N l=0.18u w=0.44u
M47 VDD s net155 VDD P l=0.18u w=0.72u
.ends SDFFNSRX2
*.SCALE meter
.GLOBAL GND VSS VDD

.subckt SDFFNSRX4 Q QN CKN D RN SE SI SN
M0 hnet37 cn net136 VDD P l=0.18u w=1.14u
M1 hnet35 cn net136 VDD P l=0.18u w=1.14u
M2 VDD m hnet37 VDD P l=0.18u w=1.14u
M3 VDD m hnet35 VDD P l=0.18u w=1.14u
M4 hnet31 m VSS VSS N l=0.18u w=0.72u
M5 hnet32 m VSS VSS N l=0.18u w=0.72u
M6 net136 c hnet31 VSS N l=0.18u w=0.72u
M7 net136 c hnet32 VSS N l=0.18u w=0.72u
M8 VDD net145 hnet42 VDD P l=0.18u w=1.42u
M9 hnet42 net136 s VDD P l=0.18u w=1.42u
M10 VDD net145 hnet39 VDD P l=0.18u w=1.42u
M11 hnet39 net136 s VDD P l=0.18u w=1.42u
M12 VDD net145 hnet46 VDD P l=0.18u w=1.02u
M13 hnet46 pm m VDD P l=0.18u w=1.02u
M14 s net145 net89 VSS N l=0.18u w=1.88u
M15 s net136 net89 VSS N l=0.18u w=1.88u
M16 net89 SN VSS VSS N l=0.18u w=1.88u
M17 m net145 net98 VSS N l=0.18u w=0.64u
M18 m pm net98 VSS N l=0.18u w=0.64u
M19 net98 SN VSS VSS N l=0.18u w=0.66u
M20 net104 SE net113 VSS N l=0.18u w=0.3u
M21 net104 D net107 VSS N l=0.18u w=0.42u
M22 net107 net147 VSS VSS N l=0.18u w=0.42u
M23 pm cn net104 VSS N l=0.18u w=0.46u
M24 net113 SI VSS VSS N l=0.18u w=0.3u
M25 s SN VDD VDD P l=0.18u w=2.14u
M26 m SN VDD VDD P l=0.18u w=0.76u
M27 net122 D net121 VDD P l=0.18u w=0.62u
M28 net121 SE VDD VDD P l=0.18u w=0.62u
M29 net122 net147 net127 VDD P l=0.18u w=0.46u
M30 pm c net122 VDD P l=0.18u w=0.62u
M31 net127 SI VDD VDD P l=0.18u w=0.46u
M32 hnet50 c net136 VDD P l=0.18u w=0.3u
M33 VDD s hnet50 VDD P l=0.18u w=0.3u
M34 hnet48 s VSS VSS N l=0.18u w=0.3u
M35 net136 cn hnet48 VSS N l=0.18u w=0.3u
M36 hnet56 cn pm VDD P l=0.18u w=0.42u
M37 VDD m hnet56 VDD P l=0.18u w=0.42u
M38 hnet54 m VSS VSS N l=0.18u w=0.3u
M39 pm c hnet54 VSS N l=0.18u w=0.3u
M40 Q net155 VSS VSS N l=0.18u w=2.4u
M41 VDD net155 Q VDD P l=0.18u w=3.52u
M42 net145 RN VSS VSS N l=0.18u w=1.06u
M43 VDD RN net145 VDD P l=0.18u w=1.52u
M44 net147 SE VSS VSS N l=0.18u w=0.28u
M45 VDD SE net147 VDD P l=0.18u w=0.46u
M46 cn c VSS VSS N l=0.18u w=0.48u
M47 VDD c cn VDD P l=0.18u w=0.72u
M48 c CKN VSS VSS N l=0.18u w=0.68u
M49 VDD CKN c VDD P l=0.18u w=1.02u
M50 QN s VSS VSS N l=0.18u w=2.4u
M51 VDD s QN VDD P l=0.18u w=3.52u
M52 net155 s VSS VSS N l=0.18u w=0.96u
M53 VDD s net155 VDD P l=0.18u w=1.44u
.ends SDFFNSRX4
*.SCALE meter
.GLOBAL GND VSS VDD

.subckt SDFFNSRXL Q QN CKN D RN SE SI SN
M0 VDD net145 hnet33 VDD P l=0.18u w=0.56u
M1 hnet33 net136 s VDD P l=0.18u w=0.56u
M2 VDD net145 hnet37 VDD P l=0.18u w=0.56u
M3 hnet37 pm m VDD P l=0.18u w=0.56u
M4 s net145 net85 VSS N l=0.18u w=0.36u
M5 s net136 net85 VSS N l=0.18u w=0.36u
M6 net85 SN VSS VSS N l=0.18u w=0.36u
M7 m net145 net94 VSS N l=0.18u w=0.36u
M8 m pm net94 VSS N l=0.18u w=0.36u
M9 net94 SN VSS VSS N l=0.18u w=0.36u
M10 net100 SE net109 VSS N l=0.18u w=0.3u
M11 net100 D net103 VSS N l=0.18u w=0.42u
M12 net103 net147 VSS VSS N l=0.18u w=0.42u
M13 pm cn net100 VSS N l=0.18u w=0.44u
M14 net109 SI VSS VSS N l=0.18u w=0.3u
M15 s SN VDD VDD P l=0.18u w=0.46u
M16 m SN VDD VDD P l=0.18u w=0.42u
M17 net118 D net121 VDD P l=0.18u w=0.52u
M18 net121 SE VDD VDD P l=0.18u w=0.52u
M19 net118 net147 net123 VDD P l=0.18u w=0.46u
M20 pm c net118 VDD P l=0.18u w=0.66u
M21 net123 SI VDD VDD P l=0.18u w=0.46u
M22 hnet41 cn net136 VDD P l=0.18u w=0.84u
M23 VDD m hnet41 VDD P l=0.18u w=0.84u
M24 hnet39 m VSS VSS N l=0.18u w=0.56u
M25 net136 c hnet39 VSS N l=0.18u w=0.56u
M26 hnet47 c net136 VDD P l=0.18u w=0.3u
M27 VDD s hnet47 VDD P l=0.18u w=0.3u
M28 hnet45 s VSS VSS N l=0.18u w=0.3u
M29 net136 cn hnet45 VSS N l=0.18u w=0.3u
M30 hnet53 cn pm VDD P l=0.18u w=0.46u
M31 VDD m hnet53 VDD P l=0.18u w=0.46u
M32 hnet51 m VSS VSS N l=0.18u w=0.3u
M33 pm c hnet51 VSS N l=0.18u w=0.3u
M34 Q net155 VSS VSS N l=0.18u w=0.42u
M35 VDD net155 Q VDD P l=0.18u w=0.64u
M36 net145 RN VSS VSS N l=0.18u w=0.3u
M37 VDD RN net145 VDD P l=0.18u w=0.42u
M38 net147 SE VSS VSS N l=0.18u w=0.3u
M39 VDD SE net147 VDD P l=0.18u w=0.42u
M40 cn c VSS VSS N l=0.18u w=0.3u
M41 VDD c cn VDD P l=0.18u w=0.46u
M42 c CKN VSS VSS N l=0.18u w=0.3u
M43 VDD CKN c VDD P l=0.18u w=0.46u
M44 QN s VSS VSS N l=0.18u w=0.42u
M45 VDD s QN VDD P l=0.18u w=0.64u
M46 net155 s VSS VSS N l=0.18u w=0.3u
M47 VDD s net155 VDD P l=0.18u w=0.42u
.ends SDFFNSRXL
*.SCALE meter
.GLOBAL GND VSS VDD

.subckt SDFFNSX1 Q QN CKN D SE SI SN
M0 VDD SN s VDD P l=0.18u w=0.66u
M1 VDD net96 s VDD P l=0.18u w=0.66u
M2 hnet29 SN VSS VSS N l=0.18u w=0.58u
M3 s net96 hnet29 VSS N l=0.18u w=0.58u
M4 VDD SN m VDD P l=0.18u w=0.32u
M5 VDD pm m VDD P l=0.18u w=0.32u
M6 hnet33 SN VSS VSS N l=0.18u w=0.3u
M7 m pm hnet33 VSS N l=0.18u w=0.3u
M8 net66 SE net75 VSS N l=0.18u w=0.3u
M9 net66 D net69 VSS N l=0.18u w=0.3u
M10 net69 net105 VSS VSS N l=0.18u w=0.3u
M11 pm cn net66 VSS N l=0.18u w=0.3u
M12 net75 SI VSS VSS N l=0.18u w=0.3u
M13 net78 D net81 VDD P l=0.18u w=0.3u
M14 net81 SE VDD VDD P l=0.18u w=0.3u
M15 net78 net105 net83 VDD P l=0.18u w=0.42u
M16 pm c net78 VDD P l=0.18u w=0.3u
M17 net83 SI VDD VDD P l=0.18u w=0.42u
M18 hnet37 cn net96 VDD P l=0.18u w=0.6u
M19 VDD m hnet37 VDD P l=0.18u w=0.6u
M20 hnet35 m VSS VSS N l=0.18u w=0.42u
M21 net96 c hnet35 VSS N l=0.18u w=0.42u
M22 hnet43 c net96 VDD P l=0.18u w=0.3u
M23 VDD s hnet43 VDD P l=0.18u w=0.3u
M24 hnet41 s VSS VSS N l=0.18u w=0.3u
M25 net96 cn hnet41 VSS N l=0.18u w=0.3u
M26 hnet49 cn pm VDD P l=0.18u w=0.42u
M27 VDD m hnet49 VDD P l=0.18u w=0.42u
M28 hnet47 m VSS VSS N l=0.18u w=0.3u
M29 pm c hnet47 VSS N l=0.18u w=0.3u
M30 Q net113 VSS VSS N l=0.18u w=0.6u
M31 VDD net113 Q VDD P l=0.18u w=0.9u
M32 net105 SE VSS VSS N l=0.18u w=0.3u
M33 VDD SE net105 VDD P l=0.18u w=0.42u
M34 cn c VSS VSS N l=0.18u w=0.3u
M35 VDD c cn VDD P l=0.18u w=0.42u
M36 c CKN VSS VSS N l=0.18u w=0.42u
M37 VDD CKN c VDD P l=0.18u w=0.6u
M38 QN s VSS VSS N l=0.18u w=0.6u
M39 VDD s QN VDD P l=0.18u w=0.9u
M40 net113 s VSS VSS N l=0.18u w=0.3u
M41 VDD s net113 VDD P l=0.18u w=0.42u
.ends SDFFNSX1
*.SCALE meter
.GLOBAL GND VSS VDD

.subckt SDFFNSX2 Q QN CKN D SE SI SN
M0 VDD SN s VDD P l=0.18u w=1.14u
M1 VDD net96 s VDD P l=0.18u w=1.14u
M2 hnet29 SN VSS VSS N l=0.18u w=1u
M3 s net96 hnet29 VSS N l=0.18u w=1u
M4 VDD SN m VDD P l=0.18u w=0.4u
M5 VDD pm m VDD P l=0.18u w=0.4u
M6 hnet33 SN VSS VSS N l=0.18u w=0.36u
M7 m pm hnet33 VSS N l=0.18u w=0.36u
M8 net66 SE net75 VSS N l=0.18u w=0.3u
M9 net66 D net69 VSS N l=0.18u w=0.3u
M10 net69 net105 VSS VSS N l=0.18u w=0.3u
M11 pm cn net66 VSS N l=0.18u w=0.3u
M12 net75 SI VSS VSS N l=0.18u w=0.3u
M13 net78 D net81 VDD P l=0.18u w=0.3u
M14 net81 SE VDD VDD P l=0.18u w=0.3u
M15 net78 net105 net83 VDD P l=0.18u w=0.42u
M16 pm c net78 VDD P l=0.18u w=0.3u
M17 net83 SI VDD VDD P l=0.18u w=0.42u
M18 hnet37 cn net96 VDD P l=0.18u w=1.02u
M19 VDD m hnet37 VDD P l=0.18u w=1.02u
M20 hnet35 m VSS VSS N l=0.18u w=0.68u
M21 net96 c hnet35 VSS N l=0.18u w=0.68u
M22 hnet43 c net96 VDD P l=0.18u w=0.3u
M23 VDD s hnet43 VDD P l=0.18u w=0.3u
M24 hnet41 s VSS VSS N l=0.18u w=0.3u
M25 net96 cn hnet41 VSS N l=0.18u w=0.3u
M26 hnet49 cn pm VDD P l=0.18u w=0.42u
M27 VDD m hnet49 VDD P l=0.18u w=0.42u
M28 hnet47 m VSS VSS N l=0.18u w=0.3u
M29 pm c hnet47 VSS N l=0.18u w=0.3u
M30 Q net113 VSS VSS N l=0.18u w=1.2u
M31 VDD net113 Q VDD P l=0.18u w=1.8u
M32 net105 SE VSS VSS N l=0.18u w=0.3u
M33 VDD SE net105 VDD P l=0.18u w=0.42u
M34 cn c VSS VSS N l=0.18u w=0.3u
M35 VDD c cn VDD P l=0.18u w=0.42u
M36 c CKN VSS VSS N l=0.18u w=0.4u
M37 VDD CKN c VDD P l=0.18u w=0.6u
M38 QN s VSS VSS N l=0.18u w=1.2u
M39 VDD s QN VDD P l=0.18u w=1.8u
M40 net113 s VSS VSS N l=0.18u w=0.48u
M41 VDD s net113 VDD P l=0.18u w=0.72u
.ends SDFFNSX2
*.SCALE meter
.GLOBAL GND VSS VDD

.subckt SDFFNSX4 Q QN CKN D SE SI SN
M0 hnet33 cn net96 VDD P l=0.18u w=0.9u
M1 hnet31 cn net96 VDD P l=0.18u w=0.9u
M2 VDD m hnet33 VDD P l=0.18u w=0.9u
M3 VDD m hnet31 VDD P l=0.18u w=0.9u
M4 hnet27 m VSS VSS N l=0.18u w=0.6u
M5 hnet28 m VSS VSS N l=0.18u w=0.6u
M6 net96 c hnet27 VSS N l=0.18u w=0.6u
M7 net96 c hnet28 VSS N l=0.18u w=0.6u
M8 VDD SN s VDD P l=0.18u w=2.12u
M9 VDD net96 s VDD P l=0.18u w=2.12u
M10 hnet38 SN VSS VSS N l=0.18u w=0.94u
M11 s net96 hnet38 VSS N l=0.18u w=0.94u
M12 hnet34 SN VSS VSS N l=0.18u w=0.94u
M13 s net96 hnet34 VSS N l=0.18u w=0.94u
M14 VDD SN m VDD P l=0.18u w=0.62u
M15 VDD pm m VDD P l=0.18u w=0.62u
M16 hnet42 SN VSS VSS N l=0.18u w=0.54u
M17 m pm hnet42 VSS N l=0.18u w=0.54u
M18 net70 SE net79 VSS N l=0.18u w=0.3u
M19 net70 D net73 VSS N l=0.18u w=0.3u
M20 net73 net105 VSS VSS N l=0.18u w=0.3u
M21 pm cn net70 VSS N l=0.18u w=0.3u
M22 net79 SI VSS VSS N l=0.18u w=0.3u
M23 net82 D net85 VDD P l=0.18u w=0.42u
M24 net85 SE VDD VDD P l=0.18u w=0.42u
M25 net82 net105 net87 VDD P l=0.18u w=0.42u
M26 pm c net82 VDD P l=0.18u w=0.42u
M27 net87 SI VDD VDD P l=0.18u w=0.42u
M28 hnet46 c net96 VDD P l=0.18u w=0.3u
M29 VDD s hnet46 VDD P l=0.18u w=0.3u
M30 hnet44 s VSS VSS N l=0.18u w=0.3u
M31 net96 cn hnet44 VSS N l=0.18u w=0.3u
M32 hnet52 cn pm VDD P l=0.18u w=0.42u
M33 VDD m hnet52 VDD P l=0.18u w=0.42u
M34 hnet50 m VSS VSS N l=0.18u w=0.3u
M35 pm c hnet50 VSS N l=0.18u w=0.3u
M36 Q net113 VSS VSS N l=0.18u w=2.4u
M37 VDD net113 Q VDD P l=0.18u w=3.54u
M38 net105 SE VSS VSS N l=0.18u w=0.3u
M39 VDD SE net105 VDD P l=0.18u w=0.42u
M40 cn c VSS VSS N l=0.18u w=0.42u
M41 VDD c cn VDD P l=0.18u w=0.6u
M42 c CKN VSS VSS N l=0.18u w=0.56u
M43 VDD CKN c VDD P l=0.18u w=0.84u
M44 QN s VSS VSS N l=0.18u w=2.4u
M45 VDD s QN VDD P l=0.18u w=3.54u
M46 net113 s VSS VSS N l=0.18u w=0.96u
M47 VDD s net113 VDD P l=0.18u w=1.44u
.ends SDFFNSX4
*.SCALE meter
.GLOBAL GND VSS VDD

.subckt SDFFNSXL Q QN CKN D SE SI SN
M0 VDD SN s VDD P l=0.18u w=0.42u
M1 VDD net96 s VDD P l=0.18u w=0.42u
M2 hnet29 SN VSS VSS N l=0.18u w=0.36u
M3 s net96 hnet29 VSS N l=0.18u w=0.36u
M4 VDD SN m VDD P l=0.18u w=0.42u
M5 VDD pm m VDD P l=0.18u w=0.42u
M6 hnet33 SN VSS VSS N l=0.18u w=0.36u
M7 m pm hnet33 VSS N l=0.18u w=0.36u
M8 net66 SE net75 VSS N l=0.18u w=0.3u
M9 net66 D net69 VSS N l=0.18u w=0.44u
M10 net69 net105 VSS VSS N l=0.18u w=0.44u
M11 pm cn net66 VSS N l=0.18u w=0.44u
M12 net75 SI VSS VSS N l=0.18u w=0.3u
M13 net78 D net81 VDD P l=0.18u w=0.66u
M14 net81 SE VDD VDD P l=0.18u w=0.66u
M15 net78 net105 net83 VDD P l=0.18u w=0.42u
M16 pm c net78 VDD P l=0.18u w=0.66u
M17 net83 SI VDD VDD P l=0.18u w=0.42u
M18 hnet37 cn net96 VDD P l=0.18u w=0.84u
M19 VDD m hnet37 VDD P l=0.18u w=0.84u
M20 hnet35 m VSS VSS N l=0.18u w=0.56u
M21 net96 c hnet35 VSS N l=0.18u w=0.56u
M22 hnet43 c net96 VDD P l=0.18u w=0.3u
M23 VDD s hnet43 VDD P l=0.18u w=0.3u
M24 hnet41 s VSS VSS N l=0.18u w=0.3u
M25 net96 cn hnet41 VSS N l=0.18u w=0.3u
M26 hnet49 cn pm VDD P l=0.18u w=0.42u
M27 VDD m hnet49 VDD P l=0.18u w=0.42u
M28 hnet47 m VSS VSS N l=0.18u w=0.3u
M29 pm c hnet47 VSS N l=0.18u w=0.3u
M30 Q net113 VSS VSS N l=0.18u w=0.42u
M31 VDD net113 Q VDD P l=0.18u w=0.64u
M32 net105 SE VSS VSS N l=0.18u w=0.3u
M33 VDD SE net105 VDD P l=0.18u w=0.42u
M34 cn c VSS VSS N l=0.18u w=0.3u
M35 VDD c cn VDD P l=0.18u w=0.42u
M36 c CKN VSS VSS N l=0.18u w=0.3u
M37 VDD CKN c VDD P l=0.18u w=0.42u
M38 QN s VSS VSS N l=0.18u w=0.42u
M39 VDD s QN VDD P l=0.18u w=0.64u
M40 net113 s VSS VSS N l=0.18u w=0.3u
M41 VDD s net113 VDD P l=0.18u w=0.42u
.ends SDFFNSXL
*.SCALE meter
.GLOBAL GND VSS VDD

.subckt SDFFNX1 Q QN CKN D SE SI
M0 net55 SE net64 VSS N l=0.18u w=0.3u
M1 net55 D net58 VSS N l=0.18u w=0.3u
M2 net58 net98 VSS VSS N l=0.18u w=0.3u
M3 pm cn net55 VSS N l=0.18u w=0.3u
M4 net64 SI VSS VSS N l=0.18u w=0.3u
M5 net67 D net70 VDD P l=0.18u w=0.3u
M6 net70 SE VDD VDD P l=0.18u w=0.3u
M7 net67 net98 net72 VDD P l=0.18u w=0.42u
M8 pm c net67 VDD P l=0.18u w=0.3u
M9 net72 SI VDD VDD P l=0.18u w=0.42u
M10 hnet27 cn net85 VDD P l=0.18u w=1.12u
M11 VDD m hnet27 VDD P l=0.18u w=1.12u
M12 hnet25 m VSS VSS N l=0.18u w=0.74u
M13 net85 c hnet25 VSS N l=0.18u w=0.74u
M14 hnet33 c net85 VDD P l=0.18u w=0.3u
M15 VDD s hnet33 VDD P l=0.18u w=0.3u
M16 hnet31 s VSS VSS N l=0.18u w=0.3u
M17 net85 cn hnet31 VSS N l=0.18u w=0.3u
M18 hnet39 cn pm VDD P l=0.18u w=0.42u
M19 VDD m hnet39 VDD P l=0.18u w=0.42u
M20 hnet37 m VSS VSS N l=0.18u w=0.3u
M21 pm c hnet37 VSS N l=0.18u w=0.3u
M22 QN s VSS VSS N l=0.18u w=0.6u
M23 VDD s QN VDD P l=0.18u w=0.9u
M24 s net85 VSS VSS N l=0.18u w=0.32u
M25 VDD net85 s VDD P l=0.18u w=0.48u
M26 m pm VSS VSS N l=0.18u w=0.3u
M27 VDD pm m VDD P l=0.18u w=0.42u
M28 net98 SE VSS VSS N l=0.18u w=0.3u
M29 VDD SE net98 VDD P l=0.18u w=0.42u
M30 cn c VSS VSS N l=0.18u w=0.3u
M31 VDD c cn VDD P l=0.18u w=0.44u
M32 c CKN VSS VSS N l=0.18u w=0.42u
M33 VDD CKN c VDD P l=0.18u w=0.64u
M34 Q net85 VSS VSS N l=0.18u w=0.58u
M35 VDD net85 Q VDD P l=0.18u w=0.9u
.ends SDFFNX1
*.SCALE meter
.GLOBAL GND VSS VDD

.subckt SDFFNX2 Q QN CKN D SE SI
M0 hnet31 cn net85 VDD P l=0.18u w=1.06u
M1 hnet29 cn net85 VDD P l=0.18u w=1.06u
M2 VDD m hnet31 VDD P l=0.18u w=1.06u
M3 VDD m hnet29 VDD P l=0.18u w=1.06u
M4 hnet25 m VSS VSS N l=0.18u w=0.7u
M5 hnet26 m VSS VSS N l=0.18u w=0.7u
M6 net85 c hnet25 VSS N l=0.18u w=0.7u
M7 net85 c hnet26 VSS N l=0.18u w=0.7u
M8 net59 SE net68 VSS N l=0.18u w=0.3u
M9 net59 D net62 VSS N l=0.18u w=0.3u
M10 net62 net98 VSS VSS N l=0.18u w=0.3u
M11 pm cn net59 VSS N l=0.18u w=0.3u
M12 net68 SI VSS VSS N l=0.18u w=0.3u
M13 net71 D net74 VDD P l=0.18u w=0.42u
M14 net74 SE VDD VDD P l=0.18u w=0.42u
M15 net71 net98 net83 VDD P l=0.18u w=0.42u
M16 pm c net71 VDD P l=0.18u w=0.42u
M17 net83 SI VDD VDD P l=0.18u w=0.42u
M18 hnet35 c net85 VDD P l=0.18u w=0.3u
M19 VDD s hnet35 VDD P l=0.18u w=0.3u
M20 hnet33 s VSS VSS N l=0.18u w=0.3u
M21 net85 cn hnet33 VSS N l=0.18u w=0.3u
M22 hnet41 cn pm VDD P l=0.18u w=0.42u
M23 VDD m hnet41 VDD P l=0.18u w=0.42u
M24 hnet39 m VSS VSS N l=0.18u w=0.3u
M25 pm c hnet39 VSS N l=0.18u w=0.3u
M26 QN s VSS VSS N l=0.18u w=1.2u
M27 VDD s QN VDD P l=0.18u w=1.8u
M28 s net85 VSS VSS N l=0.18u w=0.56u
M29 VDD net85 s VDD P l=0.18u w=0.84u
M30 m pm VSS VSS N l=0.18u w=0.46u
M31 VDD pm m VDD P l=0.18u w=0.6u
M32 net98 SE VSS VSS N l=0.18u w=0.3u
M33 VDD SE net98 VDD P l=0.18u w=0.42u
M34 cn c VSS VSS N l=0.18u w=0.44u
M35 VDD c cn VDD P l=0.18u w=0.6u
M36 c CKN VSS VSS N l=0.18u w=0.62u
M37 VDD CKN c VDD P l=0.18u w=0.92u
M38 Q net85 VSS VSS N l=0.18u w=1.16u
M39 VDD net85 Q VDD P l=0.18u w=1.8u
.ends SDFFNX2
*.SCALE meter
.GLOBAL GND VSS VDD

.subckt SDFFNX4 Q QN CKN D SE SI
M0 hnet27 cn net85 VDD P l=0.18u w=1.38u
M1 hnet29 cn net85 VDD P l=0.18u w=1.38u
M2 hnet26 cn net85 VDD P l=0.18u w=1.38u
M3 VDD m hnet27 VDD P l=0.18u w=1.38u
M4 VDD m hnet29 VDD P l=0.18u w=1.38u
M5 VDD m hnet26 VDD P l=0.18u w=1.38u
M6 hnet25 m VSS VSS N l=0.18u w=0.92u
M7 hnet28 m VSS VSS N l=0.18u w=0.92u
M8 hnet32 m VSS VSS N l=0.18u w=0.92u
M9 net85 c hnet25 VSS N l=0.18u w=0.92u
M10 net85 c hnet28 VSS N l=0.18u w=0.92u
M11 net85 c hnet32 VSS N l=0.18u w=0.92u
M12 net59 SE net68 VSS N l=0.18u w=0.3u
M13 net59 D net62 VSS N l=0.18u w=0.52u
M14 net62 net98 VSS VSS N l=0.18u w=0.52u
M15 pm cn net59 VSS N l=0.18u w=0.52u
M16 net68 SI VSS VSS N l=0.18u w=0.3u
M17 net71 D net74 VDD P l=0.18u w=0.78u
M18 net74 SE VDD VDD P l=0.18u w=0.78u
M19 net71 net98 net83 VDD P l=0.18u w=0.42u
M20 pm c net71 VDD P l=0.18u w=0.78u
M21 net83 SI VDD VDD P l=0.18u w=0.42u
M22 hnet37 c net85 VDD P l=0.18u w=0.3u
M23 VDD s hnet37 VDD P l=0.18u w=0.3u
M24 hnet35 s VSS VSS N l=0.18u w=0.3u
M25 net85 cn hnet35 VSS N l=0.18u w=0.3u
M26 hnet43 cn pm VDD P l=0.18u w=0.42u
M27 VDD m hnet43 VDD P l=0.18u w=0.42u
M28 hnet41 m VSS VSS N l=0.18u w=0.3u
M29 pm c hnet41 VSS N l=0.18u w=0.3u
M30 QN s VSS VSS N l=0.18u w=2.32u
M31 VDD s QN VDD P l=0.18u w=3.54u
M32 s net85 VSS VSS N l=0.18u w=1.04u
M33 VDD net85 s VDD P l=0.18u w=1.56u
M34 m pm VSS VSS N l=0.18u w=0.8u
M35 VDD pm m VDD P l=0.18u w=1.26u
M36 net98 SE VSS VSS N l=0.18u w=0.3u
M37 VDD SE net98 VDD P l=0.18u w=0.42u
M38 cn c VSS VSS N l=0.18u w=0.76u
M39 VDD c cn VDD P l=0.18u w=1.14u
M40 c CKN VSS VSS N l=0.18u w=1.06u
M41 VDD CKN c VDD P l=0.18u w=1.6u
M42 Q net85 VSS VSS N l=0.18u w=2.32u
M43 VDD net85 Q VDD P l=0.18u w=3.54u
.ends SDFFNX4
*.SCALE meter
.GLOBAL GND VSS VDD

.subckt SDFFNXL Q QN CKN D SE SI
M0 net55 SE net64 VSS N l=0.18u w=0.3u
M1 net55 D net58 VSS N l=0.18u w=0.44u
M2 net58 net98 VSS VSS N l=0.18u w=0.44u
M3 pm cn net55 VSS N l=0.18u w=0.44u
M4 net64 SI VSS VSS N l=0.18u w=0.3u
M5 net67 D net70 VDD P l=0.18u w=0.66u
M6 net70 SE VDD VDD P l=0.18u w=0.66u
M7 net67 net98 net72 VDD P l=0.18u w=0.42u
M8 pm c net67 VDD P l=0.18u w=0.66u
M9 net72 SI VDD VDD P l=0.18u w=0.42u
M10 hnet27 cn net85 VDD P l=0.18u w=0.84u
M11 VDD m hnet27 VDD P l=0.18u w=0.84u
M12 hnet25 m VSS VSS N l=0.18u w=0.56u
M13 net85 c hnet25 VSS N l=0.18u w=0.56u
M14 hnet33 c net85 VDD P l=0.18u w=0.3u
M15 VDD s hnet33 VDD P l=0.18u w=0.3u
M16 hnet31 s VSS VSS N l=0.18u w=0.3u
M17 net85 cn hnet31 VSS N l=0.18u w=0.3u
M18 hnet39 cn pm VDD P l=0.18u w=0.42u
M19 VDD m hnet39 VDD P l=0.18u w=0.42u
M20 hnet37 m VSS VSS N l=0.18u w=0.3u
M21 pm c hnet37 VSS N l=0.18u w=0.3u
M22 QN s VSS VSS N l=0.18u w=0.42u
M23 VDD s QN VDD P l=0.18u w=0.64u
M24 s net85 VSS VSS N l=0.18u w=0.3u
M25 VDD net85 s VDD P l=0.18u w=0.42u
M26 m pm VSS VSS N l=0.18u w=0.3u
M27 VDD pm m VDD P l=0.18u w=0.42u
M28 net98 SE VSS VSS N l=0.18u w=0.3u
M29 VDD SE net98 VDD P l=0.18u w=0.42u
M30 cn c VSS VSS N l=0.18u w=0.3u
M31 VDD c cn VDD P l=0.18u w=0.42u
M32 c CKN VSS VSS N l=0.18u w=0.3u
M33 VDD CKN c VDD P l=0.18u w=0.42u
M34 Q net85 VSS VSS N l=0.18u w=0.42u
M35 VDD net85 Q VDD P l=0.18u w=0.64u
.ends SDFFNXL
*.SCALE meter
.GLOBAL GND VSS VDD

.subckt SDFFRHQX1 Q CK D RN SE SI
M0 VDD net106 hnet27 VDD P l=0.18u w=0.64u
M1 hnet27 pm m VDD P l=0.18u w=0.64u
M2 m net106 VSS VSS N l=0.18u w=0.32u
M3 m pm VSS VSS N l=0.18u w=0.32u
M4 VDD net106 hnet31 VDD P l=0.18u w=1.2u
M5 hnet31 net115 Q VDD P l=0.18u w=1.2u
M6 Q net106 VSS VSS N l=0.18u w=0.6u
M7 Q net115 VSS VSS N l=0.18u w=0.6u
M8 VDD net106 hnet35 VDD P l=0.18u w=0.56u
M9 hnet35 net115 s VDD P l=0.18u w=0.56u
M10 s net106 VSS VSS N l=0.18u w=0.3u
M11 s net115 VSS VSS N l=0.18u w=0.3u
M12 net115 c net104 VSS N l=0.18u w=0.84u
M13 net76 SE net85 VSS N l=0.18u w=0.3u
M14 net76 D net79 VSS N l=0.18u w=0.3u
M15 net79 net108 VSS VSS N l=0.18u w=0.3u
M16 pm cn net76 VSS N l=0.18u w=0.3u
M17 net85 SI VSS VSS N l=0.18u w=0.3u
M18 net115 cn net104 VDD P l=0.18u w=1.26u
M19 net91 D net94 VDD P l=0.18u w=0.36u
M20 net94 SE VDD VDD P l=0.18u w=0.36u
M21 net91 net108 net96 VDD P l=0.18u w=0.42u
M22 pm c net91 VDD P l=0.18u w=0.36u
M23 net96 SI VDD VDD P l=0.18u w=0.42u
M24 net104 m VSS VSS N l=0.18u w=0.84u
M25 VDD m net104 VDD P l=0.18u w=1.26u
M26 net106 RN VSS VSS N l=0.18u w=0.58u
M27 VDD RN net106 VDD P l=0.18u w=0.88u
M28 net108 SE VSS VSS N l=0.18u w=0.3u
M29 VDD SE net108 VDD P l=0.18u w=0.42u
M30 c cn VSS VSS N l=0.18u w=0.3u
M31 VDD cn c VDD P l=0.18u w=0.42u
M32 cn CK VSS VSS N l=0.18u w=0.46u
M33 VDD CK cn VDD P l=0.18u w=0.68u
M34 hnet51 c net115 VDD P l=0.18u w=0.3u
M35 VDD s hnet51 VDD P l=0.18u w=0.3u
M36 hnet49 s VSS VSS N l=0.18u w=0.3u
M37 net115 cn hnet49 VSS N l=0.18u w=0.3u
M38 hnet57 cn pm VDD P l=0.18u w=0.42u
M39 VDD m hnet57 VDD P l=0.18u w=0.42u
M40 hnet55 m VSS VSS N l=0.18u w=0.3u
M41 pm c hnet55 VSS N l=0.18u w=0.3u
.ends SDFFRHQX1
*.SCALE meter
.GLOBAL GND VSS VDD

.subckt SDFFRHQX2 Q CK D RN SE SI
M0 VDD net106 hnet28 VDD P l=0.18u w=1.2u
M1 hnet28 net115 Q VDD P l=0.18u w=1.2u
M2 VDD net106 hnet26 VDD P l=0.18u w=1.2u
M3 hnet26 net115 Q VDD P l=0.18u w=1.2u
M4 Q net106 VSS VSS N l=0.18u w=1.2u
M5 Q net115 VSS VSS N l=0.18u w=1.2u
M6 VDD net106 hnet32 VDD P l=0.18u w=0.92u
M7 hnet32 pm m VDD P l=0.18u w=0.92u
M8 m net106 VSS VSS N l=0.18u w=0.46u
M9 m pm VSS VSS N l=0.18u w=0.46u
M10 VDD net106 hnet36 VDD P l=0.18u w=0.56u
M11 hnet36 net115 s VDD P l=0.18u w=0.56u
M12 s net106 VSS VSS N l=0.18u w=0.3u
M13 s net115 VSS VSS N l=0.18u w=0.3u
M14 net115 c net104 VSS N l=0.18u w=1.4u
M15 net76 SE net85 VSS N l=0.18u w=0.3u
M16 net76 D net79 VSS N l=0.18u w=0.34u
M17 net79 net108 VSS VSS N l=0.18u w=0.34u
M18 pm cn net76 VSS N l=0.18u w=0.34u
M19 net85 SI VSS VSS N l=0.18u w=0.3u
M20 net115 cn net104 VDD P l=0.18u w=2.1u
M21 net91 D net94 VDD P l=0.18u w=0.52u
M22 net94 SE VDD VDD P l=0.18u w=0.52u
M23 net91 net108 net96 VDD P l=0.18u w=0.42u
M24 pm c net91 VDD P l=0.18u w=0.52u
M25 net96 SI VDD VDD P l=0.18u w=0.42u
M26 net104 m VSS VSS N l=0.18u w=1.4u
M27 VDD m net104 VDD P l=0.18u w=2.1u
M28 net106 RN VSS VSS N l=0.18u w=0.92u
M29 VDD RN net106 VDD P l=0.18u w=1.38u
M30 net108 SE VSS VSS N l=0.18u w=0.3u
M31 VDD SE net108 VDD P l=0.18u w=0.42u
M32 c cn VSS VSS N l=0.18u w=0.4u
M33 VDD cn c VDD P l=0.18u w=0.6u
M34 cn CK VSS VSS N l=0.18u w=0.66u
M35 VDD CK cn VDD P l=0.18u w=1u
M36 hnet52 c net115 VDD P l=0.18u w=0.3u
M37 VDD s hnet52 VDD P l=0.18u w=0.3u
M38 hnet50 s VSS VSS N l=0.18u w=0.3u
M39 net115 cn hnet50 VSS N l=0.18u w=0.3u
M40 hnet58 cn pm VDD P l=0.18u w=0.42u
M41 VDD m hnet58 VDD P l=0.18u w=0.42u
M42 hnet56 m VSS VSS N l=0.18u w=0.3u
M43 pm c hnet56 VSS N l=0.18u w=0.3u
.ends SDFFRHQX2
*.SCALE meter
.GLOBAL GND VSS VDD

.subckt SDFFRHQX4 Q CK D RN SE SI
M0 VDD net106 hnet28 VDD P l=0.18u w=1.44u
M1 hnet28 net115 Q VDD P l=0.18u w=1.44u
M2 VDD net106 hnet26 VDD P l=0.18u w=1.44u
M3 hnet26 net115 Q VDD P l=0.18u w=1.44u
M4 VDD net106 hnet29 VDD P l=0.18u w=1.44u
M5 hnet29 net115 Q VDD P l=0.18u w=1.44u
M6 Q net106 VSS VSS N l=0.18u w=2.16u
M7 Q net115 VSS VSS N l=0.18u w=2.16u
M8 VDD net106 hnet33 VDD P l=0.18u w=1.56u
M9 hnet33 pm m VDD P l=0.18u w=1.56u
M10 m net106 VSS VSS N l=0.18u w=0.78u
M11 m pm VSS VSS N l=0.18u w=0.78u
M12 VDD net106 hnet37 VDD P l=0.18u w=0.56u
M13 hnet37 net115 s VDD P l=0.18u w=0.56u
M14 s net106 VSS VSS N l=0.18u w=0.3u
M15 s net115 VSS VSS N l=0.18u w=0.3u
M16 net115 c net104 VSS N l=0.18u w=2.56u
M17 net76 SE net85 VSS N l=0.18u w=0.3u
M18 net76 D net79 VSS N l=0.18u w=0.6u
M19 net79 net108 VSS VSS N l=0.18u w=0.6u
M20 pm cn net76 VSS N l=0.18u w=0.6u
M21 net85 SI VSS VSS N l=0.18u w=0.3u
M22 net115 cn net104 VDD P l=0.18u w=3.84u
M23 net91 D net90 VDD P l=0.18u w=0.86u
M24 net90 SE VDD VDD P l=0.18u w=0.86u
M25 net91 net108 net96 VDD P l=0.18u w=0.42u
M26 pm c net91 VDD P l=0.18u w=0.86u
M27 net96 SI VDD VDD P l=0.18u w=0.42u
M28 net104 m VSS VSS N l=0.18u w=2.56u
M29 VDD m net104 VDD P l=0.18u w=3.84u
M30 net106 RN VSS VSS N l=0.18u w=1.64u
M31 VDD RN net106 VDD P l=0.18u w=2.46u
M32 net108 SE VSS VSS N l=0.18u w=0.3u
M33 VDD SE net108 VDD P l=0.18u w=0.42u
M34 c cn VSS VSS N l=0.18u w=0.64u
M35 VDD cn c VDD P l=0.18u w=0.96u
M36 cn CK VSS VSS N l=0.18u w=1.06u
M37 VDD CK cn VDD P l=0.18u w=1.6u
M38 hnet53 c net115 VDD P l=0.18u w=0.3u
M39 VDD s hnet53 VDD P l=0.18u w=0.3u
M40 hnet51 s VSS VSS N l=0.18u w=0.3u
M41 net115 cn hnet51 VSS N l=0.18u w=0.3u
M42 hnet59 cn pm VDD P l=0.18u w=0.42u
M43 VDD m hnet59 VDD P l=0.18u w=0.42u
M44 hnet57 m VSS VSS N l=0.18u w=0.3u
M45 pm c hnet57 VSS N l=0.18u w=0.3u
.ends SDFFRHQX4
*.SCALE meter
.GLOBAL GND VSS VDD

.subckt SDFFRHQXL Q CK D RN SE SI
M0 VDD net106 hnet27 VDD P l=0.18u w=0.56u
M1 hnet27 pm m VDD P l=0.18u w=0.56u
M2 m net106 VSS VSS N l=0.18u w=0.3u
M3 m pm VSS VSS N l=0.18u w=0.3u
M4 VDD net106 hnet31 VDD P l=0.18u w=0.84u
M5 hnet31 net115 Q VDD P l=0.18u w=0.84u
M6 Q net106 VSS VSS N l=0.18u w=0.42u
M7 Q net115 VSS VSS N l=0.18u w=0.42u
M8 VDD net106 hnet35 VDD P l=0.18u w=0.56u
M9 hnet35 net115 s VDD P l=0.18u w=0.56u
M10 s net106 VSS VSS N l=0.18u w=0.3u
M11 s net115 VSS VSS N l=0.18u w=0.3u
M12 net115 c net104 VSS N l=0.18u w=0.56u
M13 net76 SE net85 VSS N l=0.18u w=0.3u
M14 net76 D net79 VSS N l=0.18u w=0.44u
M15 net79 net108 VSS VSS N l=0.18u w=0.44u
M16 pm cn net76 VSS N l=0.18u w=0.44u
M17 net85 SI VSS VSS N l=0.18u w=0.3u
M18 net115 cn net104 VDD P l=0.18u w=0.84u
M19 net91 D net90 VDD P l=0.18u w=0.66u
M20 net90 SE VDD VDD P l=0.18u w=0.66u
M21 net91 net108 net96 VDD P l=0.18u w=0.42u
M22 pm c net91 VDD P l=0.18u w=0.66u
M23 net96 SI VDD VDD P l=0.18u w=0.42u
M24 net104 m VSS VSS N l=0.18u w=0.3u
M25 VDD m net104 VDD P l=0.18u w=0.42u
M26 net106 RN VSS VSS N l=0.18u w=0.3u
M27 VDD RN net106 VDD P l=0.18u w=0.42u
M28 net108 SE VSS VSS N l=0.18u w=0.3u
M29 VDD SE net108 VDD P l=0.18u w=0.42u
M30 c cn VSS VSS N l=0.18u w=0.3u
M31 VDD cn c VDD P l=0.18u w=0.42u
M32 cn CK VSS VSS N l=0.18u w=0.3u
M33 VDD CK cn VDD P l=0.18u w=0.42u
M34 hnet51 c net115 VDD P l=0.18u w=0.3u
M35 VDD s hnet51 VDD P l=0.18u w=0.3u
M36 hnet49 s VSS VSS N l=0.18u w=0.3u
M37 net115 cn hnet49 VSS N l=0.18u w=0.3u
M38 hnet57 cn pm VDD P l=0.18u w=0.42u
M39 VDD m hnet57 VDD P l=0.18u w=0.42u
M40 hnet55 m VSS VSS N l=0.18u w=0.3u
M41 pm c hnet55 VSS N l=0.18u w=0.3u
.ends SDFFRHQXL
*.SCALE meter
.GLOBAL GND VSS VDD

.subckt SDFFRX1 Q QN CK D RN SE SI
M0 VDD net107 hnet28 VDD P l=0.18u w=0.88u
M1 hnet28 net98 s VDD P l=0.18u w=0.88u
M2 s net107 VSS VSS N l=0.18u w=0.44u
M3 s net98 VSS VSS N l=0.18u w=0.44u
M4 VDD net107 hnet32 VDD P l=0.18u w=0.56u
M5 hnet32 pm m VDD P l=0.18u w=0.56u
M6 m net107 VSS VSS N l=0.18u w=0.3u
M7 m pm VSS VSS N l=0.18u w=0.3u
M8 net68 SE net77 VSS N l=0.18u w=0.3u
M9 net68 D net71 VSS N l=0.18u w=0.3u
M10 net71 net109 VSS VSS N l=0.18u w=0.3u
M11 pm cn net68 VSS N l=0.18u w=0.3u
M12 net77 SI VSS VSS N l=0.18u w=0.3u
M13 net80 D net79 VDD P l=0.18u w=0.32u
M14 net79 SE VDD VDD P l=0.18u w=0.32u
M15 net80 net109 net85 VDD P l=0.18u w=0.42u
M16 pm c net80 VDD P l=0.18u w=0.32u
M17 net85 SI VDD VDD P l=0.18u w=0.42u
M18 hnet38 c net98 VDD P l=0.18u w=0.3u
M19 VDD s hnet38 VDD P l=0.18u w=0.3u
M20 hnet36 s VSS VSS N l=0.18u w=0.3u
M21 net98 cn hnet36 VSS N l=0.18u w=0.3u
M22 hnet44 cn net98 VDD P l=0.18u w=0.64u
M23 VDD m hnet44 VDD P l=0.18u w=0.64u
M24 hnet42 m VSS VSS N l=0.18u w=0.42u
M25 net98 c hnet42 VSS N l=0.18u w=0.42u
M26 hnet50 cn pm VDD P l=0.18u w=0.42u
M27 VDD m hnet50 VDD P l=0.18u w=0.42u
M28 hnet48 m VSS VSS N l=0.18u w=0.3u
M29 pm c hnet48 VSS N l=0.18u w=0.3u
M30 Q net117 VSS VSS N l=0.18u w=0.6u
M31 VDD net117 Q VDD P l=0.18u w=0.9u
M32 net107 RN VSS VSS N l=0.18u w=0.34u
M33 VDD RN net107 VDD P l=0.18u w=0.52u
M34 net109 SE VSS VSS N l=0.18u w=0.3u
M35 VDD SE net109 VDD P l=0.18u w=0.42u
M36 c cn VSS VSS N l=0.18u w=0.3u
M37 VDD cn c VDD P l=0.18u w=0.42u
M38 cn CK VSS VSS N l=0.18u w=0.4u
M39 VDD CK cn VDD P l=0.18u w=0.6u
M40 QN s VSS VSS N l=0.18u w=0.6u
M41 VDD s QN VDD P l=0.18u w=0.9u
M42 net117 s VSS VSS N l=0.18u w=0.3u
M43 VDD s net117 VDD P l=0.18u w=0.42u
.ends SDFFRX1
*.SCALE meter
.GLOBAL GND VSS VDD

.subckt SDFFRX2 Q QN CK D RN SE SI
M0 VDD net107 hnet28 VDD P l=0.18u w=1.52u
M1 hnet28 net94 s VDD P l=0.18u w=1.52u
M2 s net107 VSS VSS N l=0.18u w=0.76u
M3 s net94 VSS VSS N l=0.18u w=0.76u
M4 VDD net107 hnet32 VDD P l=0.18u w=0.56u
M5 hnet32 pm m VDD P l=0.18u w=0.56u
M6 m net107 VSS VSS N l=0.18u w=0.3u
M7 m pm VSS VSS N l=0.18u w=0.3u
M8 net68 SE net77 VSS N l=0.18u w=0.3u
M9 net68 D net71 VSS N l=0.18u w=0.3u
M10 net71 net109 VSS VSS N l=0.18u w=0.3u
M11 pm cn net68 VSS N l=0.18u w=0.3u
M12 net77 SI VSS VSS N l=0.18u w=0.3u
M13 net80 D net79 VDD P l=0.18u w=0.32u
M14 net79 SE VDD VDD P l=0.18u w=0.32u
M15 net80 net109 net85 VDD P l=0.18u w=0.42u
M16 pm c net80 VDD P l=0.18u w=0.32u
M17 net85 SI VDD VDD P l=0.18u w=0.42u
M18 hnet42 cn net94 VDD P l=0.18u w=0.54u
M19 hnet40 cn net94 VDD P l=0.18u w=0.54u
M20 VDD m hnet42 VDD P l=0.18u w=0.54u
M21 VDD m hnet40 VDD P l=0.18u w=0.54u
M22 hnet36 m VSS VSS N l=0.18u w=0.36u
M23 hnet37 m VSS VSS N l=0.18u w=0.36u
M24 net94 c hnet36 VSS N l=0.18u w=0.36u
M25 net94 c hnet37 VSS N l=0.18u w=0.36u
M26 hnet46 c net94 VDD P l=0.18u w=0.3u
M27 VDD s hnet46 VDD P l=0.18u w=0.3u
M28 hnet44 s VSS VSS N l=0.18u w=0.3u
M29 net94 cn hnet44 VSS N l=0.18u w=0.3u
M30 hnet52 cn pm VDD P l=0.18u w=0.42u
M31 VDD m hnet52 VDD P l=0.18u w=0.42u
M32 hnet50 m VSS VSS N l=0.18u w=0.3u
M33 pm c hnet50 VSS N l=0.18u w=0.3u
M34 Q net117 VSS VSS N l=0.18u w=1.08u
M35 VDD net117 Q VDD P l=0.18u w=1.8u
M36 net107 RN VSS VSS N l=0.18u w=0.5u
M37 VDD RN net107 VDD P l=0.18u w=0.76u
M38 net109 SE VSS VSS N l=0.18u w=0.3u
M39 VDD SE net109 VDD P l=0.18u w=0.42u
M40 c cn VSS VSS N l=0.18u w=0.3u
M41 VDD cn c VDD P l=0.18u w=0.44u
M42 cn CK VSS VSS N l=0.18u w=0.42u
M43 VDD CK cn VDD P l=0.18u w=0.64u
M44 QN s VSS VSS N l=0.18u w=1u
M45 VDD s QN VDD P l=0.18u w=1.8u
M46 net117 s VSS VSS N l=0.18u w=0.48u
M47 VDD s net117 VDD P l=0.18u w=0.72u
.ends SDFFRX2
*.SCALE meter
.GLOBAL GND VSS VDD

.subckt SDFFRX4 Q QN CK D RN SE SI
M0 VDD net107 hnet29 VDD P l=0.18u w=1.4u
M1 hnet29 net94 s VDD P l=0.18u w=1.4u
M2 VDD net107 hnet27 VDD P l=0.18u w=1.4u
M3 hnet27 net94 s VDD P l=0.18u w=1.4u
M4 s net107 VSS VSS N l=0.18u w=1.4u
M5 s net94 VSS VSS N l=0.18u w=1.4u
M6 VDD net107 hnet33 VDD P l=0.18u w=0.92u
M7 hnet33 pm m VDD P l=0.18u w=0.92u
M8 m net107 VSS VSS N l=0.18u w=0.46u
M9 m pm VSS VSS N l=0.18u w=0.46u
M10 net68 SE net77 VSS N l=0.18u w=0.3u
M11 net68 D net71 VSS N l=0.18u w=0.34u
M12 net71 net109 VSS VSS N l=0.18u w=0.34u
M13 pm cn net68 VSS N l=0.18u w=0.34u
M14 net77 SI VSS VSS N l=0.18u w=0.3u
M15 net80 D net83 VDD P l=0.18u w=0.52u
M16 net83 SE VDD VDD P l=0.18u w=0.52u
M17 net80 net109 net85 VDD P l=0.18u w=0.42u
M18 pm c net80 VDD P l=0.18u w=0.52u
M19 net85 SI VDD VDD P l=0.18u w=0.42u
M20 hnet43 cn net94 VDD P l=0.18u w=1u
M21 hnet41 cn net94 VDD P l=0.18u w=1u
M22 VDD m hnet43 VDD P l=0.18u w=1u
M23 VDD m hnet41 VDD P l=0.18u w=1u
M24 hnet37 m VSS VSS N l=0.18u w=0.7u
M25 hnet38 m VSS VSS N l=0.18u w=0.7u
M26 net94 c hnet37 VSS N l=0.18u w=0.7u
M27 net94 c hnet38 VSS N l=0.18u w=0.7u
M28 hnet47 c net94 VDD P l=0.18u w=0.3u
M29 VDD s hnet47 VDD P l=0.18u w=0.3u
M30 hnet45 s VSS VSS N l=0.18u w=0.3u
M31 net94 cn hnet45 VSS N l=0.18u w=0.3u
M32 hnet53 cn pm VDD P l=0.18u w=0.42u
M33 VDD m hnet53 VDD P l=0.18u w=0.42u
M34 hnet51 m VSS VSS N l=0.18u w=0.3u
M35 pm c hnet51 VSS N l=0.18u w=0.3u
M36 Q net117 VSS VSS N l=0.18u w=2.38u
M37 VDD net117 Q VDD P l=0.18u w=3.52u
M38 net107 RN VSS VSS N l=0.18u w=0.9u
M39 VDD RN net107 VDD P l=0.18u w=1.3u
M40 net109 SE VSS VSS N l=0.18u w=0.3u
M41 VDD SE net109 VDD P l=0.18u w=0.42u
M42 c cn VSS VSS N l=0.18u w=0.44u
M43 VDD cn c VDD P l=0.18u w=0.66u
M44 cn CK VSS VSS N l=0.18u w=0.62u
M45 VDD CK cn VDD P l=0.18u w=0.92u
M46 QN s VSS VSS N l=0.18u w=2.38u
M47 VDD s QN VDD P l=0.18u w=3.52u
M48 net117 s VSS VSS N l=0.19u w=0.96u
M49 VDD s net117 VDD P l=0.18u w=1.44u
.ends SDFFRX4
*.SCALE meter
.GLOBAL GND VSS VDD

.subckt SDFFRXL Q QN CK D RN SE SI
M0 VDD net107 hnet28 VDD P l=0.18u w=0.56u
M1 hnet28 net98 s VDD P l=0.18u w=0.56u
M2 s net107 VSS VSS N l=0.18u w=0.3u
M3 s net98 VSS VSS N l=0.18u w=0.3u
M4 VDD net107 hnet32 VDD P l=0.18u w=0.56u
M5 hnet32 pm m VDD P l=0.18u w=0.56u
M6 m net107 VSS VSS N l=0.18u w=0.3u
M7 m pm VSS VSS N l=0.18u w=0.3u
M8 net68 SE net77 VSS N l=0.18u w=0.3u
M9 net68 D net71 VSS N l=0.18u w=0.44u
M10 net71 net109 VSS VSS N l=0.18u w=0.44u
M11 pm cn net68 VSS N l=0.18u w=0.44u
M12 net77 SI VSS VSS N l=0.18u w=0.3u
M13 net80 D net83 VDD P l=0.18u w=0.66u
M14 net83 SE VDD VDD P l=0.18u w=0.66u
M15 net80 net109 net85 VDD P l=0.18u w=0.42u
M16 pm c net80 VDD P l=0.18u w=0.66u
M17 net85 SI VDD VDD P l=0.18u w=0.42u
M18 hnet38 cn net98 VDD P l=0.18u w=0.84u
M19 VDD m hnet38 VDD P l=0.18u w=0.84u
M20 hnet36 m VSS VSS N l=0.18u w=0.56u
M21 net98 c hnet36 VSS N l=0.18u w=0.56u
M22 hnet44 c net98 VDD P l=0.18u w=0.3u
M23 VDD s hnet44 VDD P l=0.18u w=0.3u
M24 hnet42 s VSS VSS N l=0.18u w=0.3u
M25 net98 cn hnet42 VSS N l=0.18u w=0.3u
M26 hnet50 cn pm VDD P l=0.18u w=0.42u
M27 VDD m hnet50 VDD P l=0.18u w=0.42u
M28 hnet48 m VSS VSS N l=0.18u w=0.3u
M29 pm c hnet48 VSS N l=0.18u w=0.3u
M30 Q net117 VSS VSS N l=0.18u w=0.42u
M31 VDD net117 Q VDD P l=0.18u w=0.64u
M32 net107 RN VSS VSS N l=0.18u w=0.3u
M33 VDD RN net107 VDD P l=0.18u w=0.42u
M34 net109 SE VSS VSS N l=0.18u w=0.3u
M35 VDD SE net109 VDD P l=0.18u w=0.42u
M36 c cn VSS VSS N l=0.18u w=0.3u
M37 VDD cn c VDD P l=0.18u w=0.42u
M38 cn CK VSS VSS N l=0.18u w=0.28u
M39 VDD CK cn VDD P l=0.18u w=0.4u
M40 QN s VSS VSS N l=0.18u w=0.42u
M41 VDD s QN VDD P l=0.18u w=0.64u
M42 net117 s VSS VSS N l=0.18u w=0.3u
M43 VDD s net117 VDD P l=0.18u w=0.42u
.ends SDFFRXL
*.SCALE meter
.GLOBAL GND VSS VDD

.subckt SDFFSHQX1 Q CK D SE SI SN
M0 VDD SN Q VDD P l=0.18u w=0.9u
M1 VDD net106 Q VDD P l=0.18u w=0.9u
M2 hnet28 SN VSS VSS N l=0.18u w=0.8u
M3 Q net106 hnet28 VSS N l=0.18u w=0.8u
M4 VDD SN s VDD P l=0.18u w=0.32u
M5 VDD net106 s VDD P l=0.18u w=0.32u
M6 hnet32 SN VSS VSS N l=0.18u w=0.3u
M7 s net106 hnet32 VSS N l=0.18u w=0.3u
M8 VDD SN m VDD P l=0.18u w=0.44u
M9 VDD pm m VDD P l=0.18u w=0.44u
M10 hnet36 SN VSS VSS N l=0.18u w=0.38u
M11 m pm hnet36 VSS N l=0.18u w=0.38u
M12 net106 c net97 VSS N l=0.18u w=0.74u
M13 net69 SE net78 VSS N l=0.18u w=0.3u
M14 net69 D net72 VSS N l=0.18u w=0.3u
M15 net72 net99 VSS VSS N l=0.18u w=0.3u
M16 pm cn net69 VSS N l=0.18u w=0.3u
M17 net78 SI VSS VSS N l=0.18u w=0.3u
M18 net106 cn net97 VDD P l=0.18u w=1.12u
M19 net84 D net83 VDD P l=0.18u w=0.3u
M20 net83 SE VDD VDD P l=0.18u w=0.3u
M21 net84 net99 net89 VDD P l=0.18u w=0.42u
M22 pm c net84 VDD P l=0.18u w=0.3u
M23 net89 SI VDD VDD P l=0.18u w=0.42u
M24 net97 m VSS VSS N l=0.18u w=0.74u
M25 VDD m net97 VDD P l=0.18u w=1.12u
M26 net99 SE VSS VSS N l=0.18u w=0.3u
M27 VDD SE net99 VDD P l=0.18u w=0.42u
M28 c cn VSS VSS N l=0.18u w=0.3u
M29 VDD cn c VDD P l=0.18u w=0.42u
M30 cn CK VSS VSS N l=0.18u w=0.44u
M31 VDD CK cn VDD P l=0.18u w=0.66u
M32 hnet48 c net106 VDD P l=0.18u w=0.3u
M33 VDD s hnet48 VDD P l=0.18u w=0.3u
M34 hnet46 s VSS VSS N l=0.18u w=0.3u
M35 net106 cn hnet46 VSS N l=0.18u w=0.3u
M36 hnet54 cn pm VDD P l=0.18u w=0.42u
M37 VDD m hnet54 VDD P l=0.18u w=0.42u
M38 hnet52 m VSS VSS N l=0.18u w=0.3u
M39 pm c hnet52 VSS N l=0.18u w=0.3u
.ends SDFFSHQX1
*.SCALE meter
.GLOBAL GND VSS VDD

.subckt SDFFSHQX2 Q CK D SE SI SN
M0 VDD SN Q VDD P l=0.18u w=1.76u
M1 VDD net106 Q VDD P l=0.18u w=1.76u
M2 hnet29 SN VSS VSS N l=0.18u w=0.8u
M3 Q net106 hnet29 VSS N l=0.18u w=0.8u
M4 hnet25 SN VSS VSS N l=0.18u w=0.8u
M5 Q net106 hnet25 VSS N l=0.18u w=0.8u
M6 VDD SN s VDD P l=0.18u w=0.32u
M7 VDD net106 s VDD P l=0.18u w=0.32u
M8 hnet33 SN VSS VSS N l=0.18u w=0.3u
M9 s net106 hnet33 VSS N l=0.18u w=0.3u
M10 VDD SN m VDD P l=0.18u w=0.66u
M11 VDD pm m VDD P l=0.18u w=0.66u
M12 hnet37 SN VSS VSS N l=0.18u w=0.58u
M13 m pm hnet37 VSS N l=0.18u w=0.58u
M14 net106 c net97 VSS N l=0.18u w=1.28u
M15 net69 SE net78 VSS N l=0.18u w=0.3u
M16 net69 D net72 VSS N l=0.18u w=0.32u
M17 net72 net99 VSS VSS N l=0.18u w=0.32u
M18 pm cn net69 VSS N l=0.18u w=0.32u
M19 net78 SI VSS VSS N l=0.18u w=0.3u
M20 net106 cn net97 VDD P l=0.18u w=1.92u
M21 net84 D net83 VDD P l=0.18u w=0.46u
M22 net83 SE VDD VDD P l=0.18u w=0.46u
M23 net84 net99 net89 VDD P l=0.18u w=0.42u
M24 pm c net84 VDD P l=0.18u w=0.46u
M25 net89 SI VDD VDD P l=0.18u w=0.42u
M26 net97 m VSS VSS N l=0.18u w=1.28u
M27 VDD m net97 VDD P l=0.18u w=1.92u
M28 net99 SE VSS VSS N l=0.18u w=0.3u
M29 VDD SE net99 VDD P l=0.18u w=0.42u
M30 c cn VSS VSS N l=0.18u w=0.36u
M31 VDD cn c VDD P l=0.18u w=0.54u
M32 cn CK VSS VSS N l=0.18u w=0.6u
M33 VDD CK cn VDD P l=0.18u w=0.9u
M34 hnet49 c net106 VDD P l=0.18u w=0.3u
M35 VDD s hnet49 VDD P l=0.18u w=0.3u
M36 hnet47 s VSS VSS N l=0.18u w=0.3u
M37 net106 cn hnet47 VSS N l=0.18u w=0.3u
M38 hnet55 cn pm VDD P l=0.18u w=0.42u
M39 VDD m hnet55 VDD P l=0.18u w=0.42u
M40 hnet53 m VSS VSS N l=0.18u w=0.3u
M41 pm c hnet53 VSS N l=0.18u w=0.3u
.ends SDFFSHQX2
*.SCALE meter
.GLOBAL GND VSS VDD

.subckt SDFFSHQX4 Q CK D SE SI SN
M0 VDD SN Q VDD P l=0.18u w=3.52u
M1 VDD net106 Q VDD P l=0.18u w=3.52u
M2 hnet25 SN VSS VSS N l=0.18u w=1.06u
M3 Q net106 hnet25 VSS N l=0.18u w=1.06u
M4 hnet27 SN VSS VSS N l=0.18u w=1.06u
M5 Q net106 hnet27 VSS N l=0.18u w=1.06u
M6 hnet28 SN VSS VSS N l=0.18u w=1.06u
M7 Q net106 hnet28 VSS N l=0.18u w=1.06u
M8 VDD SN s VDD P l=0.18u w=0.32u
M9 VDD net106 s VDD P l=0.18u w=0.32u
M10 hnet34 SN VSS VSS N l=0.18u w=0.3u
M11 s net106 hnet34 VSS N l=0.18u w=0.3u
M12 VDD SN m VDD P l=0.18u w=1.1u
M13 VDD pm m VDD P l=0.18u w=1.1u
M14 hnet38 SN VSS VSS N l=0.18u w=0.96u
M15 m pm hnet38 VSS N l=0.18u w=0.96u
M16 net106 c net97 VSS N l=0.18u w=2.34u
M17 net69 SE net78 VSS N l=0.18u w=0.3u
M18 net69 D net72 VSS N l=0.18u w=0.52u
M19 net72 net99 VSS VSS N l=0.18u w=0.52u
M20 pm cn net69 VSS N l=0.18u w=0.52u
M21 net78 SI VSS VSS N l=0.18u w=0.3u
M22 net106 cn net97 VDD P l=0.18u w=3.54u
M23 net84 D net83 VDD P l=0.18u w=0.76u
M24 net83 SE VDD VDD P l=0.18u w=0.76u
M25 net84 net99 net89 VDD P l=0.18u w=0.42u
M26 pm c net84 VDD P l=0.18u w=0.76u
M27 net89 SI VDD VDD P l=0.18u w=0.42u
M28 net97 m VSS VSS N l=0.18u w=2.34u
M29 VDD m net97 VDD P l=0.18u w=3.52u
M30 net99 SE VSS VSS N l=0.18u w=0.3u
M31 VDD SE net99 VDD P l=0.18u w=0.42u
M32 c cn VSS VSS N l=0.18u w=0.58u
M33 VDD cn c VDD P l=0.18u w=0.88u
M34 cn CK VSS VSS N l=0.18u w=0.98u
M35 VDD CK cn VDD P l=0.18u w=1.48u
M36 hnet50 c net106 VDD P l=0.18u w=0.3u
M37 VDD s hnet50 VDD P l=0.18u w=0.3u
M38 hnet48 s VSS VSS N l=0.18u w=0.3u
M39 net106 cn hnet48 VSS N l=0.18u w=0.3u
M40 hnet56 cn pm VDD P l=0.18u w=0.42u
M41 VDD m hnet56 VDD P l=0.18u w=0.42u
M42 hnet54 m VSS VSS N l=0.18u w=0.3u
M43 pm c hnet54 VSS N l=0.18u w=0.3u
.ends SDFFSHQX4
*.SCALE meter
.GLOBAL GND VSS VDD

.subckt SDFFSHQXL Q CK D SE SI SN
M0 VDD SN Q VDD P l=0.18u w=0.64u
M1 VDD net106 Q VDD P l=0.18u w=0.64u
M2 hnet28 SN VSS VSS N l=0.18u w=0.56u
M3 Q net106 hnet28 VSS N l=0.18u w=0.56u
M4 VDD SN s VDD P l=0.18u w=0.42u
M5 VDD net106 s VDD P l=0.18u w=0.42u
M6 hnet32 SN VSS VSS N l=0.18u w=0.36u
M7 s net106 hnet32 VSS N l=0.18u w=0.36u
M8 VDD SN m VDD P l=0.18u w=0.42u
M9 VDD pm m VDD P l=0.18u w=0.42u
M10 hnet36 SN VSS VSS N l=0.18u w=0.36u
M11 m pm hnet36 VSS N l=0.18u w=0.36u
M12 net106 c net97 VSS N l=0.18u w=0.56u
M13 net69 SE net78 VSS N l=0.18u w=0.3u
M14 net69 D net72 VSS N l=0.18u w=0.44u
M15 net72 net99 VSS VSS N l=0.18u w=0.44u
M16 pm cn net69 VSS N l=0.18u w=0.44u
M17 net78 SI VSS VSS N l=0.18u w=0.3u
M18 net106 cn net97 VDD P l=0.18u w=0.42u
M19 net84 D net83 VDD P l=0.18u w=0.66u
M20 net83 SE VDD VDD P l=0.18u w=0.66u
M21 net84 net99 net89 VDD P l=0.18u w=0.42u
M22 pm c net84 VDD P l=0.18u w=0.66u
M23 net89 SI VDD VDD P l=0.18u w=0.42u
M24 net97 m VSS VSS N l=0.18u w=0.3u
M25 VDD m net97 VDD P l=0.18u w=0.42u
M26 net99 SE VSS VSS N l=0.18u w=0.3u
M27 VDD SE net99 VDD P l=0.18u w=0.42u
M28 c cn VSS VSS N l=0.18u w=0.3u
M29 VDD cn c VDD P l=0.18u w=0.42u
M30 cn CK VSS VSS N l=0.18u w=0.3u
M31 VDD CK cn VDD P l=0.18u w=0.42u
M32 hnet48 c net106 VDD P l=0.18u w=0.3u
M33 VDD s hnet48 VDD P l=0.18u w=0.3u
M34 hnet46 s VSS VSS N l=0.18u w=0.3u
M35 net106 cn hnet46 VSS N l=0.18u w=0.3u
M36 hnet54 cn pm VDD P l=0.18u w=0.42u
M37 VDD m hnet54 VDD P l=0.18u w=0.42u
M38 hnet52 m VSS VSS N l=0.18u w=0.3u
M39 pm c hnet52 VSS N l=0.18u w=0.3u
.ends SDFFSHQXL
*.SCALE meter
.GLOBAL GND VSS VDD

.subckt SDFFSRHQX1 Q CK D RN SE SI SN
M0 VDD net167 hnet34 VDD P l=0.18u w=0.62u
M1 hnet34 pm m VDD P l=0.18u w=0.62u
M2 VDD net167 hnet38 VDD P l=0.18u w=1.2u
M3 hnet38 net176 Q VDD P l=0.18u w=1.2u
M4 s net167 net107 VSS N l=0.18u w=0.3u
M5 net176 c net165 VSS N l=0.18u w=0.82u
M6 Q net167 net101 VSS N l=0.18u w=0.8u
M7 Q net176 net101 VSS N l=0.18u w=0.8u
M8 net101 SN VSS VSS N l=0.18u w=0.8u
M9 s net176 net107 VSS N l=0.18u w=0.3u
M10 net107 SN VSS VSS N l=0.18u w=0.3u
M11 m net167 net116 VSS N l=0.18u w=0.4u
M12 m pm net116 VSS N l=0.18u w=0.4u
M13 net116 SN VSS VSS N l=0.18u w=0.4u
M14 net122 SE net131 VSS N l=0.18u w=0.3u
M15 net122 D net125 VSS N l=0.18u w=0.3u
M16 net125 net169 VSS VSS N l=0.18u w=0.3u
M17 pm cn net122 VSS N l=0.18u w=0.3u
M18 net131 SI VSS VSS N l=0.18u w=0.3u
M19 net176 cn net165 VDD P l=0.18u w=1.24u
M20 Q SN VDD VDD P l=0.18u w=0.9u
M21 s SN VDD VDD P l=0.18u w=0.3u
M22 s net176 net142 VDD P l=0.18u w=0.3u
M23 net142 net167 VDD VDD P l=0.18u w=0.3u
M24 m SN VDD VDD P l=0.18u w=0.46u
M25 net152 D net155 VDD P l=0.18u w=0.38u
M26 net155 SE VDD VDD P l=0.18u w=0.38u
M27 net152 net169 net164 VDD P l=0.18u w=0.42u
M28 pm c net152 VDD P l=0.18u w=0.38u
M29 net164 SI VDD VDD P l=0.18u w=0.42u
M30 net165 m VSS VSS N l=0.18u w=0.82u
M31 VDD m net165 VDD P l=0.18u w=1.24u
M32 net167 RN VSS VSS N l=0.18u w=0.56u
M33 VDD RN net167 VDD P l=0.18u w=0.84u
M34 net169 SE VSS VSS N l=0.18u w=0.3u
M35 VDD SE net169 VDD P l=0.18u w=0.42u
M36 c cn VSS VSS N l=0.18u w=0.3u
M37 VDD cn c VDD P l=0.18u w=0.42u
M38 cn CK VSS VSS N l=0.18u w=0.46u
M39 VDD CK cn VDD P l=0.18u w=0.68u
M40 hnet52 c net176 VDD P l=0.18u w=0.3u
M41 VDD s hnet52 VDD P l=0.18u w=0.3u
M42 hnet50 s VSS VSS N l=0.18u w=0.3u
M43 net176 cn hnet50 VSS N l=0.18u w=0.3u
M44 hnet58 cn pm VDD P l=0.18u w=0.42u
M45 VDD m hnet58 VDD P l=0.18u w=0.42u
M46 hnet56 m VSS VSS N l=0.18u w=0.3u
M47 pm c hnet56 VSS N l=0.18u w=0.3u
.ends SDFFSRHQX1
*.SCALE meter
.GLOBAL GND VSS VDD

.subckt SDFFSRHQX2 Q CK D RN SE SI SN
M0 VDD net167 hnet34 VDD P l=0.18u w=0.96u
M1 hnet34 pm m VDD P l=0.18u w=0.96u
M2 VDD net167 hnet39 VDD P l=0.18u w=1.2u
M3 hnet39 net176 Q VDD P l=0.18u w=1.2u
M4 VDD net167 hnet36 VDD P l=0.18u w=1.2u
M5 hnet36 net176 Q VDD P l=0.18u w=1.2u
M6 s net167 net107 VSS N l=0.18u w=0.3u
M7 net176 c net165 VSS N l=0.18u w=1.44u
M8 Q net167 net101 VSS N l=0.18u w=1.54u
M9 Q net176 net101 VSS N l=0.18u w=1.54u
M10 net101 SN VSS VSS N l=0.18u w=1.54u
M11 s net176 net107 VSS N l=0.18u w=0.3u
M12 net107 SN VSS VSS N l=0.18u w=0.3u
M13 m net167 net116 VSS N l=0.18u w=0.64u
M14 m pm net116 VSS N l=0.18u w=0.64u
M15 net116 SN VSS VSS N l=0.18u w=0.64u
M16 net122 SE net131 VSS N l=0.18u w=0.3u
M17 net122 D net125 VSS N l=0.18u w=0.4u
M18 net125 net169 VSS VSS N l=0.18u w=0.4u
M19 pm cn net122 VSS N l=0.18u w=0.4u
M20 net131 SI VSS VSS N l=0.18u w=0.3u
M21 net176 cn net165 VDD P l=0.18u w=2.16u
M22 Q SN VDD VDD P l=0.18u w=1.8u
M23 s SN VDD VDD P l=0.18u w=0.3u
M24 s net176 net142 VDD P l=0.18u w=0.3u
M25 net142 net167 VDD VDD P l=0.18u w=0.3u
M26 m SN VDD VDD P l=0.18u w=0.72u
M27 net152 D net155 VDD P l=0.18u w=0.6u
M28 net155 SE VDD VDD P l=0.18u w=0.6u
M29 net152 net169 net164 VDD P l=0.18u w=0.42u
M30 pm c net152 VDD P l=0.18u w=0.6u
M31 net164 SI VDD VDD P l=0.18u w=0.42u
M32 net165 m VSS VSS N l=0.18u w=1.44u
M33 VDD m net165 VDD P l=0.18u w=2.16u
M34 net167 RN VSS VSS N l=0.18u w=0.94u
M35 VDD RN net167 VDD P l=0.18u w=1.48u
M36 net169 SE VSS VSS N l=0.18u w=0.3u
M37 VDD SE net169 VDD P l=0.18u w=0.42u
M38 c cn VSS VSS N l=0.18u w=0.42u
M39 VDD cn c VDD P l=0.18u w=0.64u
M40 cn CK VSS VSS N l=0.18u w=0.68u
M41 VDD CK cn VDD P l=0.18u w=1.02u
M42 hnet53 c net176 VDD P l=0.18u w=0.3u
M43 VDD s hnet53 VDD P l=0.18u w=0.3u
M44 hnet51 s VSS VSS N l=0.18u w=0.3u
M45 net176 cn hnet51 VSS N l=0.18u w=0.3u
M46 hnet59 cn pm VDD P l=0.18u w=0.42u
M47 VDD m hnet59 VDD P l=0.18u w=0.42u
M48 hnet57 m VSS VSS N l=0.18u w=0.3u
M49 pm c hnet57 VSS N l=0.18u w=0.3u
.ends SDFFSRHQX2
*.SCALE meter
.GLOBAL GND VSS VDD

.subckt SDFFSRHQX4 Q CK D RN SE SI SN
M0 VDD net167 hnet34 VDD P l=0.18u w=1.66u
M1 hnet34 pm m VDD P l=0.18u w=1.66u
M2 VDD net167 hnet41 VDD P l=0.18u w=1.2u
M3 hnet41 net176 Q VDD P l=0.18u w=1.2u
M4 VDD net167 hnet36 VDD P l=0.18u w=1.2u
M5 hnet36 net176 Q VDD P l=0.18u w=1.2u
M6 VDD net167 hnet38 VDD P l=0.18u w=1.2u
M7 hnet38 net176 Q VDD P l=0.18u w=1.2u
M8 VDD net167 hnet37 VDD P l=0.18u w=1.2u
M9 hnet37 net176 Q VDD P l=0.18u w=1.2u
M10 s net167 net107 VSS N l=0.18u w=0.3u
M11 net176 c net165 VSS N l=0.18u w=2.16u
M12 Q net167 net101 VSS N l=0.18u w=3.07u
M13 Q net176 net101 VSS N l=0.18u w=3.06u
M14 net101 SN VSS VSS N l=0.18u w=3.06u
M15 s net176 net107 VSS N l=0.18u w=0.3u
M16 net107 SN VSS VSS N l=0.18u w=0.3u
M17 m net167 net116 VSS N l=0.18u w=1.04u
M18 m pm net116 VSS N l=0.18u w=1.04u
M19 net116 SN VSS VSS N l=0.18u w=1.1u
M20 net122 SE net131 VSS N l=0.18u w=0.3u
M21 net122 D net125 VSS N l=0.18u w=0.7u
M22 net125 net169 VSS VSS N l=0.18u w=0.7u
M23 pm cn net122 VSS N l=0.18u w=0.7u
M24 net131 SI VSS VSS N l=0.18u w=0.3u
M25 net176 cn net165 VDD P l=0.18u w=4.08u
M26 Q SN VDD VDD P l=0.18u w=3.6u
M27 s SN VDD VDD P l=0.18u w=0.3u
M28 s net176 net142 VDD P l=0.18u w=0.3u
M29 net142 net167 VDD VDD P l=0.18u w=0.3u
M30 m SN VDD VDD P l=0.18u w=1.12u
M31 net152 D net155 VDD P l=0.18u w=1.02u
M32 net155 SE VDD VDD P l=0.18u w=1.02u
M33 net152 net169 net157 VDD P l=0.18u w=0.42u
M34 pm c net152 VDD P l=0.18u w=1.02u
M35 net157 SI VDD VDD P l=0.18u w=0.42u
M36 net165 m VSS VSS N l=0.18u w=2.16u
M37 VDD m net165 VDD P l=0.18u w=4.04u
M38 net167 RN VSS VSS N l=0.18u w=1.8u
M39 VDD RN net167 VDD P l=0.18u w=2.72u
M40 net169 SE VSS VSS N l=0.18u w=0.3u
M41 VDD SE net169 VDD P l=0.18u w=0.42u
M42 c cn VSS VSS N l=0.18u w=0.68u
M43 VDD cn c VDD P l=0.18u w=1.02u
M44 cn CK VSS VSS N l=0.18u w=1.14u
M45 VDD CK cn VDD P l=0.18u w=1.64u
M46 hnet55 c net176 VDD P l=0.18u w=0.3u
M47 VDD s hnet55 VDD P l=0.18u w=0.3u
M48 hnet53 s VSS VSS N l=0.18u w=0.3u
M49 net176 cn hnet53 VSS N l=0.18u w=0.3u
M50 hnet61 cn pm VDD P l=0.18u w=0.42u
M51 VDD m hnet61 VDD P l=0.18u w=0.42u
M52 hnet59 m VSS VSS N l=0.18u w=0.3u
M53 pm c hnet59 VSS N l=0.18u w=0.3u
.ends SDFFSRHQX4
*.SCALE meter
.GLOBAL GND VSS VDD

.subckt SDFFSRHQXL Q CK D RN SE SI SN
M0 VDD net167 hnet34 VDD P l=0.18u w=0.56u
M1 hnet34 pm m VDD P l=0.18u w=0.56u
M2 VDD net167 hnet38 VDD P l=0.18u w=0.84u
M3 hnet38 net176 Q VDD P l=0.18u w=0.84u
M4 s net167 net107 VSS N l=0.18u w=0.36u
M5 net176 c net165 VSS N l=0.18u w=0.56u
M6 Q net167 net101 VSS N l=0.18u w=0.56u
M7 Q net176 net101 VSS N l=0.18u w=0.56u
M8 net101 SN VSS VSS N l=0.18u w=0.56u
M9 s net176 net107 VSS N l=0.18u w=0.36u
M10 net107 SN VSS VSS N l=0.18u w=0.36u
M11 m net167 net116 VSS N l=0.18u w=0.36u
M12 m pm net116 VSS N l=0.18u w=0.36u
M13 net116 SN VSS VSS N l=0.18u w=0.36u
M14 net122 SE net131 VSS N l=0.18u w=0.3u
M15 net122 D net125 VSS N l=0.18u w=0.44u
M16 net125 net169 VSS VSS N l=0.18u w=0.44u
M17 pm cn net122 VSS N l=0.18u w=0.44u
M18 net131 SI VSS VSS N l=0.18u w=0.3u
M19 net176 cn net165 VDD P l=0.18u w=0.84u
M20 Q SN VDD VDD P l=0.18u w=0.64u
M21 s SN VDD VDD P l=0.18u w=0.42u
M22 s net176 net142 VDD P l=0.18u w=0.56u
M23 net142 net167 VDD VDD P l=0.18u w=0.56u
M24 m SN VDD VDD P l=0.18u w=0.42u
M25 net152 D net155 VDD P l=0.18u w=0.66u
M26 net155 SE VDD VDD P l=0.18u w=0.66u
M27 net152 net169 net157 VDD P l=0.18u w=0.42u
M28 pm c net152 VDD P l=0.18u w=0.66u
M29 net157 SI VDD VDD P l=0.18u w=0.42u
M30 net165 m VSS VSS N l=0.18u w=0.3u
M31 VDD m net165 VDD P l=0.18u w=0.42u
M32 net167 RN VSS VSS N l=0.18u w=0.3u
M33 VDD RN net167 VDD P l=0.18u w=0.42u
M34 net169 SE VSS VSS N l=0.18u w=0.3u
M35 VDD SE net169 VDD P l=0.18u w=0.42u
M36 c cn VSS VSS N l=0.18u w=0.3u
M37 VDD cn c VDD P l=0.18u w=0.42u
M38 cn CK VSS VSS N l=0.18u w=0.3u
M39 VDD CK cn VDD P l=0.18u w=0.42u
M40 hnet52 c net176 VDD P l=0.18u w=0.3u
M41 VDD s hnet52 VDD P l=0.18u w=0.3u
M42 hnet50 s VSS VSS N l=0.18u w=0.3u
M43 net176 cn hnet50 VSS N l=0.18u w=0.3u
M44 hnet58 cn pm VDD P l=0.18u w=0.42u
M45 VDD m hnet58 VDD P l=0.18u w=0.42u
M46 hnet56 m VSS VSS N l=0.18u w=0.3u
M47 pm c hnet56 VSS N l=0.18u w=0.3u
.ends SDFFSRHQXL
*.SCALE meter
.GLOBAL GND VSS VDD

.subckt SDFFSRX1 Q QN CK D RN SE SI SN
M0 VDD net144 hnet33 VDD P l=0.18u w=0.88u
M1 hnet33 net135 s VDD P l=0.18u w=0.88u
M2 VDD net144 hnet37 VDD P l=0.18u w=0.4u
M3 hnet37 pm m VDD P l=0.18u w=0.4u
M4 s net144 net84 VSS N l=0.18u w=0.58u
M5 s net135 net84 VSS N l=0.18u w=0.58u
M6 net84 SN VSS VSS N l=0.18u w=0.58u
M7 m net144 net93 VSS N l=0.18u w=0.3u
M8 m pm net93 VSS N l=0.18u w=0.3u
M9 net93 SN VSS VSS N l=0.18u w=0.3u
M10 net99 SE net108 VSS N l=0.18u w=0.3u
M11 net99 D net102 VSS N l=0.18u w=0.3u
M12 net102 net146 VSS VSS N l=0.18u w=0.3u
M13 pm cn net99 VSS N l=0.18u w=0.3u
M14 net108 SI VSS VSS N l=0.18u w=0.3u
M15 s SN VDD VDD P l=0.18u w=0.66u
M16 m SN VDD VDD P l=0.18u w=0.3u
M17 net117 D net116 VDD P l=0.18u w=0.3u
M18 net116 SE VDD VDD P l=0.18u w=0.3u
M19 net117 net146 net122 VDD P l=0.18u w=0.42u
M20 pm c net117 VDD P l=0.18u w=0.3u
M21 net122 SI VDD VDD P l=0.18u w=0.42u
M22 hnet41 cn net135 VDD P l=0.18u w=0.68u
M23 VDD m hnet41 VDD P l=0.18u w=0.68u
M24 hnet39 m VSS VSS N l=0.18u w=0.46u
M25 net135 c hnet39 VSS N l=0.18u w=0.46u
M26 hnet47 c net135 VDD P l=0.18u w=0.3u
M27 VDD s hnet47 VDD P l=0.18u w=0.3u
M28 hnet45 s VSS VSS N l=0.18u w=0.3u
M29 net135 cn hnet45 VSS N l=0.18u w=0.3u
M30 hnet53 cn pm VDD P l=0.18u w=0.46u
M31 VDD m hnet53 VDD P l=0.18u w=0.46u
M32 hnet51 m VSS VSS N l=0.18u w=0.3u
M33 pm c hnet51 VSS N l=0.18u w=0.3u
M34 Q net154 VSS VSS N l=0.18u w=0.6u
M35 VDD net154 Q VDD P l=0.18u w=0.9u
M36 net144 RN VSS VSS N l=0.18u w=0.34u
M37 VDD RN net144 VDD P l=0.18u w=0.52u
M38 net146 SE VSS VSS N l=0.18u w=0.3u
M39 VDD SE net146 VDD P l=0.18u w=0.42u
M40 c cn VSS VSS N l=0.18u w=0.3u
M41 VDD cn c VDD P l=0.18u w=0.46u
M42 cn CK VSS VSS N l=0.18u w=0.4u
M43 VDD CK cn VDD P l=0.18u w=0.6u
M44 QN s VSS VSS N l=0.18u w=0.6u
M45 VDD s QN VDD P l=0.18u w=0.9u
M46 net154 s VSS VSS N l=0.18u w=0.3u
M47 VDD s net154 VDD P l=0.18u w=0.42u
.ends SDFFSRX1
*.SCALE meter
.GLOBAL GND VSS VDD

.subckt SDFFSRX2 Q QN CK D RN SE SI SN
M0 VDD net144 hnet33 VDD P l=0.18u w=1.38u
M1 hnet33 net135 s VDD P l=0.18u w=1.38u
M2 VDD net144 hnet37 VDD P l=0.18u w=0.58u
M3 hnet37 pm m VDD P l=0.18u w=0.58u
M4 s net144 net84 VSS N l=0.18u w=1u
M5 s net135 net84 VSS N l=0.18u w=1u
M6 net84 SN VSS VSS N l=0.18u w=1u
M7 m net144 net93 VSS N l=0.18u w=0.38u
M8 m pm net93 VSS N l=0.18u w=0.38u
M9 net93 SN VSS VSS N l=0.18u w=0.38u
M10 net99 SE net108 VSS N l=0.18u w=0.3u
M11 net99 D net102 VSS N l=0.18u w=0.3u
M12 net102 net146 VSS VSS N l=0.18u w=0.3u
M13 pm cn net99 VSS N l=0.18u w=0.3u
M14 net108 SI VSS VSS N l=0.18u w=0.3u
M15 s SN VDD VDD P l=0.18u w=1.14u
M16 m SN VDD VDD P l=0.18u w=0.44u
M17 net117 D net116 VDD P l=0.18u w=0.36u
M18 net116 SE VDD VDD P l=0.18u w=0.36u
M19 net117 net146 net122 VDD P l=0.18u w=0.42u
M20 pm c net117 VDD P l=0.18u w=0.36u
M21 net122 SI VDD VDD P l=0.18u w=0.42u
M22 hnet41 cn net135 VDD P l=0.18u w=1.18u
M23 VDD m hnet41 VDD P l=0.18u w=1.18u
M24 hnet39 m VSS VSS N l=0.18u w=0.8u
M25 net135 c hnet39 VSS N l=0.18u w=0.8u
M26 hnet47 c net135 VDD P l=0.18u w=0.3u
M27 VDD s hnet47 VDD P l=0.18u w=0.3u
M28 hnet45 s VSS VSS N l=0.18u w=0.3u
M29 net135 cn hnet45 VSS N l=0.18u w=0.3u
M30 hnet53 cn pm VDD P l=0.18u w=0.46u
M31 VDD m hnet53 VDD P l=0.18u w=0.46u
M32 hnet51 m VSS VSS N l=0.18u w=0.3u
M33 pm c hnet51 VSS N l=0.18u w=0.3u
M34 Q net154 VSS VSS N l=0.18u w=1.17u
M35 VDD net154 Q VDD P l=0.18u w=1.74u
M36 net144 RN VSS VSS N l=0.18u w=0.56u
M37 VDD RN net144 VDD P l=0.18u w=0.84u
M38 net146 SE VSS VSS N l=0.18u w=0.3u
M39 VDD SE net146 VDD P l=0.18u w=0.42u
M40 c cn VSS VSS N l=0.18u w=0.3u
M41 VDD cn c VDD P l=0.18u w=0.46u
M42 cn CK VSS VSS N l=0.18u w=0.42u
M43 VDD CK cn VDD P l=0.18u w=0.64u
M44 QN s VSS VSS N l=0.18u w=1.17u
M45 VDD s QN VDD P l=0.18u w=1.74u
M46 net154 s VSS VSS N l=0.18u w=0.44u
M47 VDD s net154 VDD P l=0.18u w=0.72u
.ends SDFFSRX2
*.SCALE meter
.GLOBAL GND VSS VDD

.subckt SDFFSRX4 Q QN CK D RN SE SI SN
M0 hnet37 cn net135 VDD P l=0.18u w=1.14u
M1 hnet35 cn net135 VDD P l=0.18u w=1.14u
M2 VDD m hnet37 VDD P l=0.18u w=1.14u
M3 VDD m hnet35 VDD P l=0.18u w=1.14u
M4 hnet31 m VSS VSS N l=0.18u w=0.72u
M5 hnet32 m VSS VSS N l=0.18u w=0.72u
M6 net135 c hnet31 VSS N l=0.18u w=0.72u
M7 net135 c hnet32 VSS N l=0.18u w=0.72u
M8 VDD net144 hnet42 VDD P l=0.18u w=1.42u
M9 hnet42 net135 s VDD P l=0.18u w=1.42u
M10 VDD net144 hnet39 VDD P l=0.18u w=1.42u
M11 hnet39 net135 s VDD P l=0.18u w=1.42u
M12 VDD net144 hnet46 VDD P l=0.18u w=1.02u
M13 hnet46 pm m VDD P l=0.18u w=1.02u
M14 s net144 net88 VSS N l=0.18u w=1.88u
M15 s net135 net88 VSS N l=0.18u w=1.88u
M16 net88 SN VSS VSS N l=0.18u w=1.88u
M17 m net144 net97 VSS N l=0.18u w=0.64u
M18 m pm net97 VSS N l=0.18u w=0.64u
M19 net97 SN VSS VSS N l=0.18u w=0.66u
M20 net103 SE net112 VSS N l=0.18u w=0.3u
M21 net103 D net106 VSS N l=0.18u w=0.42u
M22 net106 net146 VSS VSS N l=0.18u w=0.42u
M23 pm cn net103 VSS N l=0.18u w=0.46u
M24 net112 SI VSS VSS N l=0.18u w=0.3u
M25 s SN VDD VDD P l=0.18u w=2.14u
M26 m SN VDD VDD P l=0.18u w=0.76u
M27 net121 D net120 VDD P l=0.18u w=0.62u
M28 net120 SE VDD VDD P l=0.18u w=0.62u
M29 net121 net146 net126 VDD P l=0.18u w=0.46u
M30 pm c net121 VDD P l=0.18u w=0.62u
M31 net126 SI VDD VDD P l=0.18u w=0.46u
M32 hnet50 c net135 VDD P l=0.18u w=0.3u
M33 VDD s hnet50 VDD P l=0.18u w=0.3u
M34 hnet48 s VSS VSS N l=0.18u w=0.3u
M35 net135 cn hnet48 VSS N l=0.18u w=0.3u
M36 hnet56 cn pm VDD P l=0.18u w=0.42u
M37 VDD m hnet56 VDD P l=0.18u w=0.42u
M38 hnet54 m VSS VSS N l=0.18u w=0.3u
M39 pm c hnet54 VSS N l=0.18u w=0.3u
M40 Q net154 VSS VSS N l=0.18u w=2.4u
M41 VDD net154 Q VDD P l=0.18u w=3.52u
M42 net144 RN VSS VSS N l=0.18u w=1.06u
M43 VDD RN net144 VDD P l=0.18u w=1.52u
M44 net146 SE VSS VSS N l=0.18u w=0.28u
M45 VDD SE net146 VDD P l=0.18u w=0.46u
M46 c cn VSS VSS N l=0.18u w=0.48u
M47 VDD cn c VDD P l=0.18u w=0.72u
M48 cn CK VSS VSS N l=0.18u w=0.68u
M49 VDD CK cn VDD P l=0.18u w=1.02u
M50 QN s VSS VSS N l=0.18u w=2.4u
M51 VDD s QN VDD P l=0.18u w=3.52u
M52 net154 s VSS VSS N l=0.18u w=0.96u
M53 VDD s net154 VDD P l=0.18u w=1.44u
.ends SDFFSRX4
*.SCALE meter
.GLOBAL GND VSS VDD

.subckt SDFFSRXL Q QN CK D RN SE SI SN
M0 VDD net144 hnet33 VDD P l=0.18u w=0.56u
M1 hnet33 net135 s VDD P l=0.18u w=0.56u
M2 VDD net144 hnet37 VDD P l=0.18u w=0.56u
M3 hnet37 pm m VDD P l=0.18u w=0.56u
M4 s net144 net84 VSS N l=0.18u w=0.36u
M5 s net135 net84 VSS N l=0.18u w=0.36u
M6 net84 SN VSS VSS N l=0.18u w=0.36u
M7 m net144 net93 VSS N l=0.18u w=0.36u
M8 m pm net93 VSS N l=0.18u w=0.36u
M9 net93 SN VSS VSS N l=0.18u w=0.36u
M10 net99 SE net108 VSS N l=0.18u w=0.3u
M11 net99 D net102 VSS N l=0.18u w=0.42u
M12 net102 net146 VSS VSS N l=0.18u w=0.42u
M13 pm cn net99 VSS N l=0.18u w=0.46u
M14 net108 SI VSS VSS N l=0.18u w=0.3u
M15 s SN VDD VDD P l=0.18u w=0.46u
M16 m SN VDD VDD P l=0.18u w=0.42u
M17 net117 D net116 VDD P l=0.18u w=0.52u
M18 net116 SE VDD VDD P l=0.18u w=0.52u
M19 net117 net146 net122 VDD P l=0.18u w=0.46u
M20 pm c net117 VDD P l=0.18u w=0.66u
M21 net122 SI VDD VDD P l=0.18u w=0.46u
M22 hnet41 cn net135 VDD P l=0.18u w=0.84u
M23 VDD m hnet41 VDD P l=0.18u w=0.84u
M24 hnet39 m VSS VSS N l=0.18u w=0.56u
M25 net135 c hnet39 VSS N l=0.18u w=0.56u
M26 hnet47 c net135 VDD P l=0.18u w=0.3u
M27 VDD s hnet47 VDD P l=0.18u w=0.3u
M28 hnet45 s VSS VSS N l=0.18u w=0.3u
M29 net135 cn hnet45 VSS N l=0.18u w=0.3u
M30 hnet53 cn pm VDD P l=0.18u w=0.46u
M31 VDD m hnet53 VDD P l=0.18u w=0.46u
M32 hnet51 m VSS VSS N l=0.18u w=0.3u
M33 pm c hnet51 VSS N l=0.18u w=0.3u
M34 Q net154 VSS VSS N l=0.18u w=0.42u
M35 VDD net154 Q VDD P l=0.18u w=0.64u
M36 net144 RN VSS VSS N l=0.18u w=0.3u
M37 VDD RN net144 VDD P l=0.18u w=0.42u
M38 net146 SE VSS VSS N l=0.18u w=0.3u
M39 VDD SE net146 VDD P l=0.18u w=0.42u
M40 c cn VSS VSS N l=0.18u w=0.3u
M41 VDD cn c VDD P l=0.18u w=0.44u
M42 cn CK VSS VSS N l=0.18u w=0.3u
M43 VDD CK cn VDD P l=0.18u w=0.46u
M44 QN s VSS VSS N l=0.18u w=0.42u
M45 VDD s QN VDD P l=0.18u w=0.64u
M46 net154 s VSS VSS N l=0.18u w=0.3u
M47 VDD s net154 VDD P l=0.18u w=0.42u
.ends SDFFSRXL
*.SCALE meter
.GLOBAL GND VSS VDD

.subckt SDFFSX1 Q QN CK D SE SI SN
M0 VDD SN s VDD P l=0.18u w=0.66u
M1 VDD net95 s VDD P l=0.18u w=0.66u
M2 hnet29 SN VSS VSS N l=0.18u w=0.58u
M3 s net95 hnet29 VSS N l=0.18u w=0.58u
M4 VDD SN m VDD P l=0.18u w=0.32u
M5 VDD pm m VDD P l=0.18u w=0.32u
M6 hnet33 SN VSS VSS N l=0.18u w=0.3u
M7 m pm hnet33 VSS N l=0.18u w=0.3u
M8 net65 SE net74 VSS N l=0.18u w=0.3u
M9 net65 D net68 VSS N l=0.18u w=0.3u
M10 net68 net104 VSS VSS N l=0.18u w=0.3u
M11 pm cn net65 VSS N l=0.18u w=0.3u
M12 net74 SI VSS VSS N l=0.18u w=0.3u
M13 net77 D net80 VDD P l=0.18u w=0.3u
M14 net80 SE VDD VDD P l=0.18u w=0.3u
M15 net77 net104 net82 VDD P l=0.18u w=0.42u
M16 pm c net77 VDD P l=0.18u w=0.3u
M17 net82 SI VDD VDD P l=0.18u w=0.42u
M18 hnet37 cn net95 VDD P l=0.18u w=0.6u
M19 VDD m hnet37 VDD P l=0.18u w=0.6u
M20 hnet35 m VSS VSS N l=0.18u w=0.42u
M21 net95 c hnet35 VSS N l=0.18u w=0.42u
M22 hnet43 c net95 VDD P l=0.18u w=0.3u
M23 VDD s hnet43 VDD P l=0.18u w=0.3u
M24 hnet41 s VSS VSS N l=0.18u w=0.3u
M25 net95 cn hnet41 VSS N l=0.18u w=0.3u
M26 hnet49 cn pm VDD P l=0.18u w=0.42u
M27 VDD m hnet49 VDD P l=0.18u w=0.42u
M28 hnet47 m VSS VSS N l=0.18u w=0.3u
M29 pm c hnet47 VSS N l=0.18u w=0.3u
M30 Q net112 VSS VSS N l=0.18u w=0.6u
M31 VDD net112 Q VDD P l=0.18u w=0.9u
M32 net104 SE VSS VSS N l=0.18u w=0.3u
M33 VDD SE net104 VDD P l=0.18u w=0.42u
M34 c cn VSS VSS N l=0.18u w=0.3u
M35 VDD cn c VDD P l=0.18u w=0.42u
M36 cn CK VSS VSS N l=0.18u w=0.42u
M37 VDD CK cn VDD P l=0.18u w=0.6u
M38 QN s VSS VSS N l=0.18u w=0.54u
M39 VDD s QN VDD P l=0.18u w=0.86u
M40 net112 s VSS VSS N l=0.18u w=0.3u
M41 VDD s net112 VDD P l=0.18u w=0.42u
.ends SDFFSX1
*.SCALE meter
.GLOBAL GND VSS VDD

.subckt SDFFSX2 Q QN CK D SE SI SN
M0 VDD SN s VDD P l=0.18u w=1.14u
M1 VDD net95 s VDD P l=0.18u w=1.14u
M2 hnet29 SN VSS VSS N l=0.18u w=1u
M3 s net95 hnet29 VSS N l=0.18u w=1u
M4 VDD SN m VDD P l=0.18u w=0.42u
M5 VDD pm m VDD P l=0.18u w=0.42u
M6 hnet33 SN VSS VSS N l=0.18u w=0.36u
M7 m pm hnet33 VSS N l=0.18u w=0.36u
M8 net65 SE net74 VSS N l=0.18u w=0.3u
M9 net65 D net68 VSS N l=0.18u w=0.3u
M10 net68 net104 VSS VSS N l=0.18u w=0.3u
M11 pm cn net65 VSS N l=0.18u w=0.3u
M12 net74 SI VSS VSS N l=0.18u w=0.3u
M13 net77 D net80 VDD P l=0.18u w=0.3u
M14 net80 SE VDD VDD P l=0.18u w=0.3u
M15 net77 net104 net82 VDD P l=0.18u w=0.42u
M16 pm c net77 VDD P l=0.18u w=0.3u
M17 net82 SI VDD VDD P l=0.18u w=0.42u
M18 hnet37 cn net95 VDD P l=0.18u w=1.02u
M19 VDD m hnet37 VDD P l=0.18u w=1.02u
M20 hnet35 m VSS VSS N l=0.18u w=0.68u
M21 net95 c hnet35 VSS N l=0.18u w=0.68u
M22 hnet43 c net95 VDD P l=0.18u w=0.3u
M23 VDD s hnet43 VDD P l=0.18u w=0.3u
M24 hnet41 s VSS VSS N l=0.18u w=0.3u
M25 net95 cn hnet41 VSS N l=0.18u w=0.3u
M26 hnet49 cn pm VDD P l=0.18u w=0.42u
M27 VDD m hnet49 VDD P l=0.18u w=0.42u
M28 hnet47 m VSS VSS N l=0.18u w=0.3u
M29 pm c hnet47 VSS N l=0.18u w=0.3u
M30 Q net112 VSS VSS N l=0.18u w=1.2u
M31 VDD net112 Q VDD P l=0.18u w=1.76u
M32 net104 SE VSS VSS N l=0.18u w=0.3u
M33 VDD SE net104 VDD P l=0.18u w=0.42u
M34 c cn VSS VSS N l=0.18u w=0.3u
M35 VDD cn c VDD P l=0.18u w=0.42u
M36 cn CK VSS VSS N l=0.18u w=0.42u
M37 VDD CK cn VDD P l=0.18u w=0.6u
M38 QN s VSS VSS N l=0.18u w=1.2u
M39 VDD s QN VDD P l=0.18u w=1.76u
M40 net112 s VSS VSS N l=0.18u w=0.48u
M41 VDD s net112 VDD P l=0.18u w=0.72u
.ends SDFFSX2
*.SCALE meter
.GLOBAL GND VSS VDD

.subckt SDFFSX4 Q QN CK D SE SI SN
M0 hnet33 cn net95 VDD P l=0.18u w=0.9u
M1 hnet31 cn net95 VDD P l=0.18u w=0.9u
M2 VDD m hnet33 VDD P l=0.18u w=0.9u
M3 VDD m hnet31 VDD P l=0.18u w=0.9u
M4 hnet27 m VSS VSS N l=0.18u w=0.6u
M5 hnet28 m VSS VSS N l=0.18u w=0.6u
M6 net95 c hnet27 VSS N l=0.18u w=0.6u
M7 net95 c hnet28 VSS N l=0.18u w=0.6u
M8 VDD SN s VDD P l=0.18u w=2.12u
M9 VDD net95 s VDD P l=0.18u w=2.12u
M10 hnet38 SN VSS VSS N l=0.18u w=0.94u
M11 s net95 hnet38 VSS N l=0.18u w=0.94u
M12 hnet34 SN VSS VSS N l=0.18u w=0.94u
M13 s net95 hnet34 VSS N l=0.18u w=0.94u
M14 VDD SN m VDD P l=0.18u w=0.62u
M15 VDD pm m VDD P l=0.18u w=0.62u
M16 hnet42 SN VSS VSS N l=0.18u w=0.52u
M17 m pm hnet42 VSS N l=0.18u w=0.52u
M18 net69 SE net78 VSS N l=0.18u w=0.3u
M19 net69 D net72 VSS N l=0.18u w=0.3u
M20 net72 net104 VSS VSS N l=0.18u w=0.3u
M21 pm cn net69 VSS N l=0.18u w=0.3u
M22 net78 SI VSS VSS N l=0.18u w=0.3u
M23 net81 D net84 VDD P l=0.18u w=0.42u
M24 net84 SE VDD VDD P l=0.18u w=0.42u
M25 net81 net104 net86 VDD P l=0.18u w=0.42u
M26 pm c net81 VDD P l=0.18u w=0.42u
M27 net86 SI VDD VDD P l=0.18u w=0.42u
M28 hnet46 c net95 VDD P l=0.18u w=0.3u
M29 VDD s hnet46 VDD P l=0.18u w=0.3u
M30 hnet44 s VSS VSS N l=0.18u w=0.3u
M31 net95 cn hnet44 VSS N l=0.18u w=0.3u
M32 hnet52 cn pm VDD P l=0.18u w=0.42u
M33 VDD m hnet52 VDD P l=0.18u w=0.42u
M34 hnet50 m VSS VSS N l=0.18u w=0.3u
M35 pm c hnet50 VSS N l=0.18u w=0.3u
M36 Q net112 VSS VSS N l=0.18u w=2.4u
M37 VDD net112 Q VDD P l=0.18u w=3.6u
M38 net104 SE VSS VSS N l=0.18u w=0.3u
M39 VDD SE net104 VDD P l=0.18u w=0.42u
M40 c cn VSS VSS N l=0.18u w=0.4u
M41 VDD cn c VDD P l=0.18u w=0.6u
M42 cn CK VSS VSS N l=0.18u w=0.56u
M43 VDD CK cn VDD P l=0.18u w=0.84u
M44 QN s VSS VSS N l=0.18u w=2.4u
M45 VDD s QN VDD P l=0.18u w=3.6u
M46 net112 s VSS VSS N l=0.18u w=0.96u
M47 VDD s net112 VDD P l=0.18u w=1.44u
.ends SDFFSX4
*.SCALE meter
.GLOBAL GND VSS VDD

.subckt SDFFSXL Q QN CK D SE SI SN
M0 VDD SN s VDD P l=0.18u w=0.42u
M1 VDD net95 s VDD P l=0.18u w=0.42u
M2 hnet29 SN VSS VSS N l=0.18u w=0.36u
M3 s net95 hnet29 VSS N l=0.18u w=0.36u
M4 VDD SN m VDD P l=0.18u w=0.42u
M5 VDD pm m VDD P l=0.18u w=0.42u
M6 hnet33 SN VSS VSS N l=0.18u w=0.36u
M7 m pm hnet33 VSS N l=0.18u w=0.36u
M8 net65 SE net74 VSS N l=0.18u w=0.3u
M9 net65 D net68 VSS N l=0.18u w=0.44u
M10 net68 net104 VSS VSS N l=0.18u w=0.44u
M11 pm cn net65 VSS N l=0.18u w=0.44u
M12 net74 SI VSS VSS N l=0.18u w=0.3u
M13 net77 D net80 VDD P l=0.18u w=0.66u
M14 net80 SE VDD VDD P l=0.18u w=0.66u
M15 net77 net104 net82 VDD P l=0.18u w=0.42u
M16 pm c net77 VDD P l=0.18u w=0.66u
M17 net82 SI VDD VDD P l=0.18u w=0.42u
M18 hnet37 cn net95 VDD P l=0.18u w=0.84u
M19 VDD m hnet37 VDD P l=0.18u w=0.84u
M20 hnet35 m VSS VSS N l=0.18u w=0.56u
M21 net95 c hnet35 VSS N l=0.18u w=0.56u
M22 hnet43 c net95 VDD P l=0.18u w=0.3u
M23 VDD s hnet43 VDD P l=0.18u w=0.3u
M24 hnet41 s VSS VSS N l=0.18u w=0.3u
M25 net95 cn hnet41 VSS N l=0.18u w=0.3u
M26 hnet49 cn pm VDD P l=0.18u w=0.42u
M27 VDD m hnet49 VDD P l=0.18u w=0.42u
M28 hnet47 m VSS VSS N l=0.18u w=0.3u
M29 pm c hnet47 VSS N l=0.18u w=0.3u
M30 Q net112 VSS VSS N l=0.18u w=0.42u
M31 VDD net112 Q VDD P l=0.18u w=0.64u
M32 net104 SE VSS VSS N l=0.18u w=0.3u
M33 VDD SE net104 VDD P l=0.18u w=0.42u
M34 c cn VSS VSS N l=0.18u w=0.3u
M35 VDD cn c VDD P l=0.18u w=0.42u
M36 cn CK VSS VSS N l=0.18u w=0.3u
M37 VDD CK cn VDD P l=0.18u w=0.42u
M38 QN s VSS VSS N l=0.18u w=0.42u
M39 VDD s QN VDD P l=0.18u w=0.64u
M40 net112 s VSS VSS N l=0.18u w=0.3u
M41 VDD s net112 VDD P l=0.18u w=0.42u
.ends SDFFSXL
*.SCALE meter
.GLOBAL GND VSS VDD

.subckt SDFFTRX1 Q QN CK D RN SE SI
M0 net63 net115 net72 VSS N l=0.18u w=0.3u
M1 net69 SE net78 VSS N l=0.18u w=0.3u
M2 net69 D net63 VSS N l=0.18u w=0.3u
M3 net72 RN VSS VSS N l=0.18u w=0.3u
M4 pm cn net69 VSS N l=0.18u w=0.3u
M5 net78 SI VSS VSS N l=0.18u w=0.3u
M6 net84 RN net83 VDD P l=0.18u w=0.3u
M7 net84 D net83 VDD P l=0.18u w=0.3u
M8 net83 SE VDD VDD P l=0.18u w=0.3u
M9 net84 net115 net89 VDD P l=0.18u w=0.42u
M10 pm c net84 VDD P l=0.18u w=0.3u
M11 net89 SI VDD VDD P l=0.18u w=0.42u
M12 hnet29 cn net98 VDD P l=0.18u w=1.12u
M13 VDD m hnet29 VDD P l=0.18u w=1.12u
M14 hnet27 m VSS VSS N l=0.18u w=0.74u
M15 net98 c hnet27 VSS N l=0.18u w=0.74u
M16 hnet35 c net98 VDD P l=0.18u w=0.3u
M17 VDD s hnet35 VDD P l=0.18u w=0.3u
M18 hnet33 s VSS VSS N l=0.18u w=0.3u
M19 net98 cn hnet33 VSS N l=0.18u w=0.3u
M20 hnet41 cn pm VDD P l=0.18u w=0.42u
M21 VDD m hnet41 VDD P l=0.18u w=0.42u
M22 hnet39 m VSS VSS N l=0.18u w=0.3u
M23 pm c hnet39 VSS N l=0.18u w=0.3u
M24 QN s VSS VSS N l=0.18u w=0.6u
M25 VDD s QN VDD P l=0.18u w=0.9u
M26 s net98 VSS VSS N l=0.18u w=0.32u
M27 VDD net98 s VDD P l=0.18u w=0.48u
M28 m pm VSS VSS N l=0.18u w=0.3u
M29 VDD pm m VDD P l=0.18u w=0.46u
M30 net115 SE VSS VSS N l=0.18u w=0.3u
M31 VDD SE net115 VDD P l=0.18u w=0.42u
M32 c cn VSS VSS N l=0.18u w=0.3u
M33 VDD cn c VDD P l=0.18u w=0.46u
M34 cn CK VSS VSS N l=0.18u w=0.46u
M35 VDD CK cn VDD P l=0.18u w=0.66u
M36 Q net98 VSS VSS N l=0.18u w=0.56u
M37 VDD net98 Q VDD P l=0.18u w=0.9u
.ends SDFFTRX1
*.SCALE meter
.GLOBAL GND VSS VDD

.subckt SDFFTRX2 Q QN CK D RN SE SI
M0 hnet33 cn net62 VDD P l=0.18u w=1.04u
M1 hnet31 cn net62 VDD P l=0.18u w=1.04u
M2 VDD m hnet33 VDD P l=0.18u w=1.04u
M3 VDD m hnet31 VDD P l=0.18u w=1.04u
M4 hnet27 m VSS VSS N l=0.18u w=0.7u
M5 hnet28 m VSS VSS N l=0.18u w=0.7u
M6 net62 c hnet27 VSS N l=0.18u w=0.7u
M7 net62 c hnet28 VSS N l=0.18u w=0.7u
M8 net67 net115 net76 VSS N l=0.18u w=0.3u
M9 net73 SE net82 VSS N l=0.18u w=0.3u
M10 net73 D net67 VSS N l=0.18u w=0.3u
M11 net76 RN VSS VSS N l=0.18u w=0.3u
M12 pm cn net73 VSS N l=0.18u w=0.3u
M13 net82 SI VSS VSS N l=0.18u w=0.3u
M14 net88 RN net87 VDD P l=0.18u w=0.46u
M15 net88 D net87 VDD P l=0.18u w=0.46u
M16 net87 SE VDD VDD P l=0.18u w=0.42u
M17 net88 net115 net93 VDD P l=0.18u w=0.46u
M18 pm c net88 VDD P l=0.18u w=0.46u
M19 net93 SI VDD VDD P l=0.18u w=0.46u
M20 hnet37 c net62 VDD P l=0.18u w=0.3u
M21 VDD s hnet37 VDD P l=0.18u w=0.3u
M22 hnet35 s VSS VSS N l=0.18u w=0.3u
M23 net62 cn hnet35 VSS N l=0.18u w=0.3u
M24 hnet43 cn pm VDD P l=0.18u w=0.46u
M25 VDD m hnet43 VDD P l=0.18u w=0.46u
M26 hnet41 m VSS VSS N l=0.18u w=0.3u
M27 pm c hnet41 VSS N l=0.18u w=0.3u
M28 QN s VSS VSS N l=0.18u w=1.2u
M29 VDD s QN VDD P l=0.18u w=1.76u
M30 s net62 VSS VSS N l=0.18u w=0.56u
M31 VDD net62 s VDD P l=0.18u w=0.84u
M32 m pm VSS VSS N l=0.18u w=0.42u
M33 VDD pm m VDD P l=0.18u w=0.68u
M34 net115 SE VSS VSS N l=0.18u w=0.3u
M35 VDD SE net115 VDD P l=0.18u w=0.46u
M36 c cn VSS VSS N l=0.18u w=0.38u
M37 VDD cn c VDD P l=0.18u w=0.56u
M38 cn CK VSS VSS N l=0.18u w=0.64u
M39 VDD CK cn VDD P l=0.18u w=0.96u
M40 Q net62 VSS VSS N l=0.18u w=1.2u
M41 VDD net62 Q VDD P l=0.18u w=1.76u
.ends SDFFTRX2
*.SCALE meter
.GLOBAL GND VSS VDD

.subckt SDFFTRX4 Q QN CK D RN SE SI
M0 hnet29 cn net62 VDD P l=0.18u w=1.24u
M1 hnet31 cn net62 VDD P l=0.18u w=1.24u
M2 hnet28 cn net62 VDD P l=0.18u w=1.24u
M3 VDD m hnet29 VDD P l=0.18u w=1.24u
M4 VDD m hnet31 VDD P l=0.18u w=1.24u
M5 VDD m hnet28 VDD P l=0.18u w=1.24u
M6 hnet27 m VSS VSS N l=0.18u w=0.84u
M7 hnet30 m VSS VSS N l=0.18u w=0.84u
M8 hnet34 m VSS VSS N l=0.18u w=0.84u
M9 net62 c hnet27 VSS N l=0.18u w=0.84u
M10 net62 c hnet30 VSS N l=0.18u w=0.84u
M11 net62 c hnet34 VSS N l=0.18u w=0.84u
M12 net67 net115 net76 VSS N l=0.18u w=0.56u
M13 net73 SE net82 VSS N l=0.18u w=0.3u
M14 net73 D net67 VSS N l=0.18u w=0.56u
M15 net76 RN VSS VSS N l=0.18u w=0.56u
M16 pm cn net73 VSS N l=0.18u w=0.56u
M17 net82 SI VSS VSS N l=0.18u w=0.3u
M18 net88 RN net87 VDD P l=0.18u w=0.78u
M19 net88 D net87 VDD P l=0.18u w=0.78u
M20 net87 SE VDD VDD P l=0.18u w=0.78u
M21 net88 net115 net93 VDD P l=0.18u w=0.42u
M22 pm c net88 VDD P l=0.18u w=0.78u
M23 net93 SI VDD VDD P l=0.18u w=0.42u
M24 hnet39 c net62 VDD P l=0.18u w=0.3u
M25 VDD s hnet39 VDD P l=0.18u w=0.3u
M26 hnet37 s VSS VSS N l=0.18u w=0.3u
M27 net62 cn hnet37 VSS N l=0.18u w=0.3u
M28 hnet45 cn pm VDD P l=0.18u w=0.42u
M29 VDD m hnet45 VDD P l=0.18u w=0.42u
M30 hnet43 m VSS VSS N l=0.18u w=0.3u
M31 pm c hnet43 VSS N l=0.18u w=0.3u
M32 QN s VSS VSS N l=0.18u w=2.4u
M33 VDD s QN VDD P l=0.18u w=3.6u
M34 s net62 VSS VSS N l=0.18u w=1.04u
M35 VDD net62 s VDD P l=0.18u w=1.56u
M36 m pm VSS VSS N l=0.18u w=0.84u
M37 VDD pm m VDD P l=0.18u w=1.26u
M38 net115 SE VSS VSS N l=0.18u w=0.3u
M39 VDD SE net115 VDD P l=0.18u w=0.42u
M40 c cn VSS VSS N l=0.18u w=0.66u
M41 VDD cn c VDD P l=0.18u w=1u
M42 cn CK VSS VSS N l=0.18u w=1.12u
M43 VDD CK cn VDD P l=0.18u w=1.68u
M44 Q net62 VSS VSS N l=0.18u w=2.4u
M45 VDD net62 Q VDD P l=0.18u w=3.6u
.ends SDFFTRX4
*.SCALE meter
.GLOBAL GND VSS VDD

.subckt SDFFTRXL Q QN CK D RN SE SI
M0 net63 net115 net72 VSS N l=0.18u w=0.48u
M1 net69 SE net78 VSS N l=0.18u w=0.3u
M2 net69 D net63 VSS N l=0.18u w=0.48u
M3 net72 RN VSS VSS N l=0.18u w=0.48u
M4 pm cn net69 VSS N l=0.18u w=0.48u
M5 net78 SI VSS VSS N l=0.18u w=0.3u
M6 net84 RN net83 VDD P l=0.18u w=0.6u
M7 net84 D net83 VDD P l=0.18u w=0.6u
M8 net83 SE VDD VDD P l=0.18u w=0.66u
M9 net84 net115 net89 VDD P l=0.18u w=0.42u
M10 pm c net84 VDD P l=0.18u w=0.66u
M11 net89 SI VDD VDD P l=0.18u w=0.42u
M12 hnet29 cn net98 VDD P l=0.18u w=0.84u
M13 VDD m hnet29 VDD P l=0.18u w=0.84u
M14 hnet27 m VSS VSS N l=0.18u w=0.56u
M15 net98 c hnet27 VSS N l=0.18u w=0.56u
M16 hnet35 c net98 VDD P l=0.18u w=0.3u
M17 VDD s hnet35 VDD P l=0.18u w=0.3u
M18 hnet33 s VSS VSS N l=0.18u w=0.3u
M19 net98 cn hnet33 VSS N l=0.18u w=0.3u
M20 hnet41 cn pm VDD P l=0.18u w=0.42u
M21 VDD m hnet41 VDD P l=0.18u w=0.42u
M22 hnet39 m VSS VSS N l=0.18u w=0.3u
M23 pm c hnet39 VSS N l=0.18u w=0.3u
M24 QN s VSS VSS N l=0.18u w=0.42u
M25 VDD s QN VDD P l=0.18u w=0.64u
M26 s net98 VSS VSS N l=0.18u w=0.3u
M27 VDD net98 s VDD P l=0.18u w=0.42u
M28 m pm VSS VSS N l=0.18u w=0.28u
M29 VDD pm m VDD P l=0.18u w=0.46u
M30 net115 SE VSS VSS N l=0.18u w=0.3u
M31 VDD SE net115 VDD P l=0.18u w=0.42u
M32 c cn VSS VSS N l=0.18u w=0.28u
M33 VDD cn c VDD P l=0.18u w=0.46u
M34 cn CK VSS VSS N l=0.18u w=0.3u
M35 VDD CK cn VDD P l=0.18u w=0.42u
M36 Q net98 VSS VSS N l=0.18u w=0.46u
M37 VDD net98 Q VDD P l=0.18u w=0.64u
.ends SDFFTRXL
*.SCALE meter
.GLOBAL GND VSS VDD

.subckt SDFFX1 Q QN CK D SE SI
M0 net55 SE net64 VSS N l=0.18u w=0.3u
M1 net55 D net58 VSS N l=0.18u w=0.3u
M2 net58 net98 VSS VSS N l=0.18u w=0.3u
M3 pm cn net55 VSS N l=0.18u w=0.3u
M4 net64 SI VSS VSS N l=0.18u w=0.3u
M5 net67 D net70 VDD P l=0.18u w=0.3u
M6 net70 SE VDD VDD P l=0.18u w=0.3u
M7 net67 net98 net72 VDD P l=0.18u w=0.42u
M8 pm c net67 VDD P l=0.18u w=0.3u
M9 net72 SI VDD VDD P l=0.18u w=0.42u
M10 hnet27 cn net85 VDD P l=0.18u w=1.12u
M11 VDD m hnet27 VDD P l=0.18u w=1.12u
M12 hnet25 m VSS VSS N l=0.18u w=0.74u
M13 net85 c hnet25 VSS N l=0.18u w=0.74u
M14 hnet33 c net85 VDD P l=0.18u w=0.3u
M15 VDD s hnet33 VDD P l=0.18u w=0.3u
M16 hnet31 s VSS VSS N l=0.18u w=0.3u
M17 net85 cn hnet31 VSS N l=0.18u w=0.3u
M18 hnet39 cn pm VDD P l=0.18u w=0.42u
M19 VDD m hnet39 VDD P l=0.18u w=0.42u
M20 hnet37 m VSS VSS N l=0.18u w=0.3u
M21 pm c hnet37 VSS N l=0.18u w=0.3u
M22 QN s VSS VSS N l=0.18u w=0.6u
M23 VDD s QN VDD P l=0.18u w=0.9u
M24 s net85 VSS VSS N l=0.18u w=0.32u
M25 VDD net85 s VDD P l=0.18u w=0.48u
M26 m pm VSS VSS N l=0.18u w=0.3u
M27 VDD pm m VDD P l=0.18u w=0.42u
M28 net98 SE VSS VSS N l=0.18u w=0.3u
M29 VDD SE net98 VDD P l=0.18u w=0.42u
M30 c cn VSS VSS N l=0.18u w=0.3u
M31 VDD cn c VDD P l=0.18u w=0.44u
M32 cn CK VSS VSS N l=0.18u w=0.42u
M33 VDD CK cn VDD P l=0.18u w=0.64u
M34 Q net85 VSS VSS N l=0.18u w=0.58u
M35 VDD net85 Q VDD P l=0.18u w=0.9u
.ends SDFFX1
*.SCALE meter
.GLOBAL GND VSS VDD

.subckt SDFFX2 Q QN CK D SE SI
M0 hnet31 cn net85 VDD P l=0.18u w=1.06u
M1 hnet29 cn net85 VDD P l=0.18u w=1.06u
M2 VDD m hnet31 VDD P l=0.18u w=1.06u
M3 VDD m hnet29 VDD P l=0.18u w=1.06u
M4 hnet25 m VSS VSS N l=0.18u w=0.7u
M5 hnet26 m VSS VSS N l=0.18u w=0.7u
M6 net85 c hnet25 VSS N l=0.18u w=0.7u
M7 net85 c hnet26 VSS N l=0.18u w=0.7u
M8 net59 SE net68 VSS N l=0.18u w=0.3u
M9 net59 D net62 VSS N l=0.18u w=0.3u
M10 net62 net98 VSS VSS N l=0.18u w=0.3u
M11 pm cn net59 VSS N l=0.18u w=0.3u
M12 net68 SI VSS VSS N l=0.18u w=0.3u
M13 net71 D net74 VDD P l=0.18u w=0.42u
M14 net74 SE VDD VDD P l=0.18u w=0.42u
M15 net71 net98 net83 VDD P l=0.18u w=0.42u
M16 pm c net71 VDD P l=0.18u w=0.42u
M17 net83 SI VDD VDD P l=0.18u w=0.42u
M18 hnet35 c net85 VDD P l=0.18u w=0.3u
M19 VDD s hnet35 VDD P l=0.18u w=0.3u
M20 hnet33 s VSS VSS N l=0.18u w=0.3u
M21 net85 cn hnet33 VSS N l=0.18u w=0.3u
M22 hnet41 cn pm VDD P l=0.18u w=0.42u
M23 VDD m hnet41 VDD P l=0.18u w=0.42u
M24 hnet39 m VSS VSS N l=0.18u w=0.3u
M25 pm c hnet39 VSS N l=0.18u w=0.3u
M26 QN s VSS VSS N l=0.18u w=1.2u
M27 VDD s QN VDD P l=0.18u w=1.8u
M28 s net85 VSS VSS N l=0.18u w=0.56u
M29 VDD net85 s VDD P l=0.18u w=0.84u
M30 m pm VSS VSS N l=0.18u w=0.46u
M31 VDD pm m VDD P l=0.18u w=0.6u
M32 net98 SE VSS VSS N l=0.18u w=0.3u
M33 VDD SE net98 VDD P l=0.18u w=0.42u
M34 c cn VSS VSS N l=0.18u w=0.44u
M35 VDD cn c VDD P l=0.18u w=0.6u
M36 cn CK VSS VSS N l=0.18u w=0.62u
M37 VDD CK cn VDD P l=0.18u w=0.92u
M38 Q net85 VSS VSS N l=0.18u w=1.16u
M39 VDD net85 Q VDD P l=0.18u w=1.8u
.ends SDFFX2
*.SCALE meter
.GLOBAL GND VSS VDD

.subckt SDFFX4 Q QN CK D SE SI
M0 hnet27 cn net85 VDD P l=0.18u w=1.38u
M1 hnet29 cn net85 VDD P l=0.18u w=1.38u
M2 hnet26 cn net85 VDD P l=0.18u w=1.38u
M3 VDD m hnet27 VDD P l=0.18u w=1.38u
M4 VDD m hnet29 VDD P l=0.18u w=1.38u
M5 VDD m hnet26 VDD P l=0.18u w=1.38u
M6 hnet25 m VSS VSS N l=0.18u w=0.92u
M7 hnet28 m VSS VSS N l=0.18u w=0.92u
M8 hnet32 m VSS VSS N l=0.18u w=0.92u
M9 net85 c hnet25 VSS N l=0.18u w=0.92u
M10 net85 c hnet28 VSS N l=0.18u w=0.92u
M11 net85 c hnet32 VSS N l=0.18u w=0.92u
M12 net59 SE net68 VSS N l=0.18u w=0.3u
M13 net59 D net62 VSS N l=0.18u w=0.52u
M14 net62 net98 VSS VSS N l=0.18u w=0.52u
M15 pm cn net59 VSS N l=0.18u w=0.52u
M16 net68 SI VSS VSS N l=0.18u w=0.3u
M17 net71 D net74 VDD P l=0.18u w=0.78u
M18 net74 SE VDD VDD P l=0.18u w=0.78u
M19 net71 net98 net83 VDD P l=0.18u w=0.42u
M20 pm c net71 VDD P l=0.18u w=0.78u
M21 net83 SI VDD VDD P l=0.18u w=0.42u
M22 hnet37 c net85 VDD P l=0.18u w=0.3u
M23 VDD s hnet37 VDD P l=0.18u w=0.3u
M24 hnet35 s VSS VSS N l=0.18u w=0.3u
M25 net85 cn hnet35 VSS N l=0.18u w=0.3u
M26 hnet43 cn pm VDD P l=0.18u w=0.42u
M27 VDD m hnet43 VDD P l=0.18u w=0.42u
M28 hnet41 m VSS VSS N l=0.18u w=0.3u
M29 pm c hnet41 VSS N l=0.18u w=0.3u
M30 QN s VSS VSS N l=0.18u w=2.4u
M31 VDD s QN VDD P l=0.18u w=3.48u
M32 s net85 VSS VSS N l=0.18u w=1.04u
M33 VDD net85 s VDD P l=0.18u w=1.56u
M34 m pm VSS VSS N l=0.18u w=0.84u
M35 VDD pm m VDD P l=0.18u w=1.26u
M36 net98 SE VSS VSS N l=0.18u w=0.3u
M37 VDD SE net98 VDD P l=0.18u w=0.42u
M38 c cn VSS VSS N l=0.18u w=0.76u
M39 VDD cn c VDD P l=0.18u w=1.14u
M40 cn CK VSS VSS N l=0.18u w=1.06u
M41 VDD CK cn VDD P l=0.18u w=1.6u
M42 Q net85 VSS VSS N l=0.18u w=2.4u
M43 VDD net85 Q VDD P l=0.18u w=3.48u
.ends SDFFX4
*.SCALE meter
.GLOBAL GND VSS VDD

.subckt SDFFXL Q QN CK D SE SI
M0 net55 SE net64 VSS N l=0.18u w=0.3u
M1 net55 D net58 VSS N l=0.18u w=0.44u
M2 net58 net98 VSS VSS N l=0.18u w=0.44u
M3 pm cn net55 VSS N l=0.18u w=0.44u
M4 net64 SI VSS VSS N l=0.18u w=0.3u
M5 net67 D net70 VDD P l=0.18u w=0.66u
M6 net70 SE VDD VDD P l=0.18u w=0.66u
M7 net67 net98 net72 VDD P l=0.18u w=0.42u
M8 pm c net67 VDD P l=0.18u w=0.66u
M9 net72 SI VDD VDD P l=0.18u w=0.42u
M10 hnet27 cn net85 VDD P l=0.18u w=0.84u
M11 VDD m hnet27 VDD P l=0.18u w=0.84u
M12 hnet25 m VSS VSS N l=0.18u w=0.56u
M13 net85 c hnet25 VSS N l=0.18u w=0.56u
M14 hnet33 c net85 VDD P l=0.18u w=0.3u
M15 VDD s hnet33 VDD P l=0.18u w=0.3u
M16 hnet31 s VSS VSS N l=0.18u w=0.3u
M17 net85 cn hnet31 VSS N l=0.18u w=0.3u
M18 hnet39 cn pm VDD P l=0.18u w=0.42u
M19 VDD m hnet39 VDD P l=0.18u w=0.42u
M20 hnet37 m VSS VSS N l=0.18u w=0.3u
M21 pm c hnet37 VSS N l=0.18u w=0.3u
M22 QN s VSS VSS N l=0.18u w=0.38u
M23 VDD s QN VDD P l=0.18u w=0.64u
M24 s net85 VSS VSS N l=0.18u w=0.3u
M25 VDD net85 s VDD P l=0.18u w=0.42u
M26 m pm VSS VSS N l=0.18u w=0.3u
M27 VDD pm m VDD P l=0.18u w=0.42u
M28 net98 SE VSS VSS N l=0.18u w=0.3u
M29 VDD SE net98 VDD P l=0.18u w=0.42u
M30 c cn VSS VSS N l=0.18u w=0.3u
M31 VDD cn c VDD P l=0.18u w=0.42u
M32 cn CK VSS VSS N l=0.18u w=0.28u
M33 VDD CK cn VDD P l=0.18u w=0.46u
M34 Q net85 VSS VSS N l=0.18u w=0.42u
M35 VDD net85 Q VDD P l=0.18u w=0.64u
.ends SDFFXL
*.SCALE meter
.GLOBAL GND VSS VDD

.subckt SEDFFHQX1 Q CK D E SE SI
M0 hnet31 cn pm VDD P l=0.18u w=0.42u
M1 VDD m hnet31 VDD P l=0.18u w=0.42u
M2 hnet29 m VSS VSS N l=0.18u w=0.3u
M3 pm c hnet29 VSS N l=0.18u w=0.3u
M4 hnet37 c net83 VDD P l=0.18u w=0.3u
M5 VDD s hnet37 VDD P l=0.18u w=0.3u
M6 hnet35 s VSS VSS N l=0.18u w=0.3u
M7 net83 cn hnet35 VSS N l=0.18u w=0.3u
M8 net83 cn net128 VDD P l=0.18u w=1.62u
M9 net94 net118 VDD VDD P l=0.18u w=0.56u
M10 net94 c pm VDD P l=0.18u w=0.56u
M11 net118 net144 net140 VDD P l=0.18u w=0.42u
M12 net118 net142 net124 VDD P l=0.18u w=0.66u
M13 net124 net146 s VDD P l=0.18u w=0.66u
M14 net124 net148 net150 VDD P l=0.18u w=0.66u
M15 net83 c net128 VSS N l=0.18u w=1.08u
M16 net112 net118 VSS VSS N l=0.18u w=0.36u
M17 pm cn net112 VSS N l=0.18u w=0.36u
M18 net118 net142 net140 VSS N l=0.18u w=0.3u
M19 net118 net144 net124 VSS N l=0.18u w=0.44u
M20 net124 net148 s VSS N l=0.18u w=0.44u
M21 net124 net146 net150 VSS N l=0.18u w=0.44u
M22 net128 m VSS VSS N l=0.18u w=0.92u
M23 VDD m net128 VDD P l=0.18u w=1.62u
M24 m pm VSS VSS N l=0.18u w=0.38u
M25 VDD pm m VDD P l=0.18u w=0.56u
M26 s net83 VSS VSS N l=0.18u w=0.76u
M27 VDD net83 s VDD P l=0.18u w=1.14u
M28 Q s VSS VSS N l=0.18u w=0.6u
M29 VDD s Q VDD P l=0.18u w=0.9u
M30 c cn VSS VSS N l=0.18u w=0.34u
M31 VDD cn c VDD P l=0.18u w=0.52u
M32 cn CK VSS VSS N l=0.18u w=0.56u
M33 VDD CK cn VDD P l=0.18u w=0.84u
M34 net140 SI VSS VSS N l=0.18u w=0.3u
M35 VDD SI net140 VDD P l=0.18u w=0.42u
M36 net142 net144 VSS VSS N l=0.18u w=0.3u
M37 VDD net144 net142 VDD P l=0.18u w=0.42u
M38 net144 SE VSS VSS N l=0.18u w=0.3u
M39 VDD SE net144 VDD P l=0.18u w=0.42u
M40 net146 net148 VSS VSS N l=0.18u w=0.3u
M41 VDD net148 net146 VDD P l=0.18u w=0.42u
M42 net148 E VSS VSS N l=0.18u w=0.3u
M43 VDD E net148 VDD P l=0.18u w=0.42u
M44 net150 D VSS VSS N l=0.18u w=0.44u
M45 VDD D net150 VDD P l=0.18u w=0.66u
.ends SEDFFHQX1
*.SCALE meter
.GLOBAL GND VSS VDD

.subckt SEDFFHQX2 Q CK D E SE SI
M0 hnet31 cn pm VDD P l=0.18u w=0.42u
M1 VDD m hnet31 VDD P l=0.18u w=0.42u
M2 hnet29 m VSS VSS N l=0.18u w=0.3u
M3 pm c hnet29 VSS N l=0.18u w=0.3u
M4 hnet37 c net83 VDD P l=0.18u w=0.3u
M5 VDD s hnet37 VDD P l=0.18u w=0.3u
M6 hnet35 s VSS VSS N l=0.18u w=0.3u
M7 net83 cn hnet35 VSS N l=0.18u w=0.3u
M8 net83 cn net128 VDD P l=0.18u w=2.6u
M9 net94 net118 VDD VDD P l=0.18u w=0.56u
M10 net94 c pm VDD P l=0.18u w=0.56u
M11 net118 net144 net140 VDD P l=0.18u w=0.42u
M12 net118 net142 net124 VDD P l=0.18u w=0.66u
M13 net124 net146 s VDD P l=0.18u w=0.66u
M14 net124 net148 net150 VDD P l=0.18u w=0.66u
M15 net83 c net128 VSS N l=0.18u w=1.72u
M16 net112 net118 VSS VSS N l=0.18u w=0.36u
M17 pm cn net112 VSS N l=0.18u w=0.36u
M18 net118 net142 net140 VSS N l=0.18u w=0.3u
M19 net118 net144 net124 VSS N l=0.18u w=0.44u
M20 net124 net148 s VSS N l=0.18u w=0.44u
M21 net124 net146 net150 VSS N l=0.18u w=0.44u
M22 net128 m VSS VSS N l=0.18u w=1.72u
M23 VDD m net128 VDD P l=0.18u w=2.6u
M24 m pm VSS VSS N l=0.18u w=0.56u
M25 VDD pm m VDD P l=0.18u w=0.84u
M26 s net83 VSS VSS N l=0.18u w=0.9u
M27 VDD net83 s VDD P l=0.18u w=1.5u
M28 Q s VSS VSS N l=0.18u w=1.2u
M29 VDD s Q VDD P l=0.18u w=1.8u
M30 c cn VSS VSS N l=0.18u w=0.46u
M31 VDD cn c VDD P l=0.18u w=0.66u
M32 cn CK VSS VSS N l=0.18u w=0.76u
M33 VDD CK cn VDD P l=0.18u w=1.14u
M34 net140 SI VSS VSS N l=0.18u w=0.3u
M35 VDD SI net140 VDD P l=0.18u w=0.42u
M36 net142 net144 VSS VSS N l=0.18u w=0.3u
M37 VDD net144 net142 VDD P l=0.18u w=0.42u
M38 net144 SE VSS VSS N l=0.18u w=0.3u
M39 VDD SE net144 VDD P l=0.18u w=0.42u
M40 net146 net148 VSS VSS N l=0.18u w=0.3u
M41 VDD net148 net146 VDD P l=0.18u w=0.42u
M42 net148 E VSS VSS N l=0.18u w=0.3u
M43 VDD E net148 VDD P l=0.18u w=0.42u
M44 net150 D VSS VSS N l=0.18u w=0.44u
M45 VDD D net150 VDD P l=0.18u w=0.66u
.ends SEDFFHQX2
*.SCALE meter
.GLOBAL GND VSS VDD

.subckt SEDFFHQX4 Q CK D E SE SI
M0 hnet31 cn pm VDD P l=0.18u w=0.42u
M1 VDD m hnet31 VDD P l=0.18u w=0.42u
M2 hnet29 m VSS VSS N l=0.18u w=0.3u
M3 pm c hnet29 VSS N l=0.18u w=0.3u
M4 hnet37 c net83 VDD P l=0.18u w=0.3u
M5 VDD s hnet37 VDD P l=0.18u w=0.3u
M6 hnet35 s VSS VSS N l=0.18u w=0.3u
M7 net83 cn hnet35 VSS N l=0.18u w=0.3u
M8 net83 cn net128 VDD P l=0.18u w=4.38u
M9 net94 net118 VDD VDD P l=0.18u w=0.56u
M10 net94 c pm VDD P l=0.18u w=0.56u
M11 net118 net144 net140 VDD P l=0.18u w=0.42u
M12 net118 net142 net124 VDD P l=0.18u w=0.66u
M13 net124 net146 s VDD P l=0.18u w=0.66u
M14 net124 net148 net150 VDD P l=0.18u w=0.66u
M15 net83 c net128 VSS N l=0.18u w=3.06u
M16 net112 net118 VSS VSS N l=0.18u w=0.36u
M17 pm cn net112 VSS N l=0.18u w=0.36u
M18 net118 net142 net140 VSS N l=0.18u w=0.3u
M19 net118 net144 net124 VSS N l=0.18u w=0.44u
M20 net124 net148 s VSS N l=0.18u w=0.44u
M21 net124 net146 net150 VSS N l=0.18u w=0.44u
M22 net128 m VSS VSS N l=0.18u w=3.06u
M23 VDD m net128 VDD P l=0.18u w=4.62u
M24 m pm VSS VSS N l=0.18u w=0.92u
M25 VDD pm m VDD P l=0.18u w=1.4u
M26 s net83 VSS VSS N l=0.18u w=1.48u
M27 VDD net83 s VDD P l=0.18u w=2.24u
M28 Q s VSS VSS N l=0.18u w=2.4u
M29 VDD s Q VDD P l=0.18u w=3.6u
M30 c cn VSS VSS N l=0.18u w=0.66u
M31 VDD cn c VDD P l=0.18u w=1u
M32 cn CK VSS VSS N l=0.18u w=1.16u
M33 VDD CK cn VDD P l=0.18u w=1.74u
M34 net140 SI VSS VSS N l=0.18u w=0.3u
M35 VDD SI net140 VDD P l=0.18u w=0.42u
M36 net142 net144 VSS VSS N l=0.18u w=0.3u
M37 VDD net144 net142 VDD P l=0.18u w=0.42u
M38 net144 SE VSS VSS N l=0.18u w=0.3u
M39 VDD SE net144 VDD P l=0.18u w=0.42u
M40 net146 net148 VSS VSS N l=0.18u w=0.3u
M41 VDD net148 net146 VDD P l=0.18u w=0.42u
M42 net148 E VSS VSS N l=0.18u w=0.3u
M43 VDD E net148 VDD P l=0.18u w=0.42u
M44 net150 D VSS VSS N l=0.18u w=0.44u
M45 VDD D net150 VDD P l=0.18u w=0.66u
.ends SEDFFHQX4
*.SCALE meter
.GLOBAL GND VSS VDD

.subckt SEDFFHQXL Q CK D E SE SI
M0 hnet31 cn pm VDD P l=0.18u w=0.42u
M1 VDD m hnet31 VDD P l=0.18u w=0.42u
M2 hnet29 m VSS VSS N l=0.18u w=0.3u
M3 pm c hnet29 VSS N l=0.18u w=0.3u
M4 hnet37 c net83 VDD P l=0.18u w=0.3u
M5 VDD s hnet37 VDD P l=0.18u w=0.3u
M6 hnet35 s VSS VSS N l=0.18u w=0.3u
M7 net83 cn hnet35 VSS N l=0.18u w=0.3u
M8 net83 cn net128 VDD P l=0.18u w=0.84u
M9 net94 net118 VDD VDD P l=0.18u w=0.56u
M10 net94 c pm VDD P l=0.18u w=0.56u
M11 net118 net144 net140 VDD P l=0.18u w=0.84u
M12 net118 net142 net124 VDD P l=0.18u w=0.8u
M13 net124 net146 s VDD P l=0.18u w=0.84u
M14 net124 net148 net150 VDD P l=0.18u w=0.84u
M15 net83 c net128 VSS N l=0.18u w=0.56u
M16 net112 net118 VSS VSS N l=0.18u w=0.36u
M17 pm cn net112 VSS N l=0.18u w=0.36u
M18 net118 net142 net140 VSS N l=0.18u w=0.56u
M19 net118 net144 net124 VSS N l=0.18u w=0.5u
M20 net124 net148 s VSS N l=0.18u w=0.56u
M21 net124 net146 net150 VSS N l=0.18u w=0.56u
M22 net128 m VSS VSS N l=0.18u w=0.3u
M23 VDD m net128 VDD P l=0.18u w=0.42u
M24 m pm VSS VSS N l=0.18u w=0.3u
M25 VDD pm m VDD P l=0.18u w=0.42u
M26 s net83 VSS VSS N l=0.18u w=0.3u
M27 VDD net83 s VDD P l=0.18u w=0.42u
M28 Q s VSS VSS N l=0.18u w=0.42u
M29 VDD s Q VDD P l=0.18u w=0.64u
M30 c cn VSS VSS N l=0.18u w=0.3u
M31 VDD cn c VDD P l=0.18u w=0.42u
M32 cn CK VSS VSS N l=0.18u w=0.3u
M33 VDD CK cn VDD P l=0.18u w=0.42u
M34 net140 SI VSS VSS N l=0.18u w=0.3u
M35 VDD SI net140 VDD P l=0.18u w=0.42u
M36 net142 net144 VSS VSS N l=0.18u w=0.3u
M37 VDD net144 net142 VDD P l=0.18u w=0.42u
M38 net144 SE VSS VSS N l=0.18u w=0.3u
M39 VDD SE net144 VDD P l=0.18u w=0.42u
M40 net146 net148 VSS VSS N l=0.18u w=0.3u
M41 VDD net148 net146 VDD P l=0.18u w=0.42u
M42 net148 E VSS VSS N l=0.18u w=0.3u
M43 VDD E net148 VDD P l=0.18u w=0.42u
M44 net150 D VSS VSS N l=0.18u w=0.3u
M45 VDD D net150 VDD P l=0.18u w=0.42u
.ends SEDFFHQXL
*.SCALE meter
.GLOBAL GND VSS VDD

.subckt SEDFFTRX1 Q QN CK D E RN SE SI
M0 VDD SE hnet33 VDD P l=0.18u w=0.56u
M1 hnet33 RN net91 VDD P l=0.18u w=0.56u
M2 net91 SE VSS VSS N l=0.18u w=0.3u
M3 net91 RN VSS VSS N l=0.18u w=0.3u
M4 hnet39 cn pm VDD P l=0.18u w=0.42u
M5 VDD m hnet39 VDD P l=0.18u w=0.42u
M6 hnet37 m VSS VSS N l=0.18u w=0.3u
M7 pm c hnet37 VSS N l=0.18u w=0.3u
M8 hnet45 c net131 VDD P l=0.18u w=0.3u
M9 VDD s hnet45 VDD P l=0.18u w=0.3u
M10 hnet43 s VSS VSS N l=0.18u w=0.3u
M11 net131 cn hnet43 VSS N l=0.18u w=0.3u
M12 net104 net140 net113 VDD P l=0.18u w=0.66u
M13 net131 cn net152 VDD P l=0.18u w=1.72u
M14 net104 net91 VDD VDD P l=0.18u w=0.66u
M15 net113 c pm VDD P l=0.18u w=0.66u
M16 net140 net168 net164 VDD P l=0.18u w=0.42u
M17 net140 net166 net146 VDD P l=0.18u w=0.72u
M18 net146 net170 s VDD P l=0.18u w=0.72u
M19 net146 net172 net174 VDD P l=0.18u w=0.72u
M20 net128 net91 VSS VSS N l=0.18u w=0.36u
M21 net131 c net152 VSS N l=0.18u w=1.14u
M22 net128 net140 VSS VSS N l=0.18u w=0.36u
M23 pm cn net128 VSS N l=0.18u w=0.36u
M24 net140 net166 net164 VSS N l=0.18u w=0.3u
M25 net140 net168 net146 VSS N l=0.18u w=0.48u
M26 net146 net172 s VSS N l=0.18u w=0.48u
M27 net146 net170 net174 VSS N l=0.18u w=1.19u
M28 QN net131 VSS VSS N l=0.18u w=0.6u
M29 VDD net131 QN VDD P l=0.18u w=0.9u
M30 net152 m VSS VSS N l=0.18u w=1.14u
M31 VDD m net152 VDD P l=0.18u w=1.72u
M32 m pm VSS VSS N l=0.18u w=0.42u
M33 VDD pm m VDD P l=0.18u w=0.6u
M34 s net131 VSS VSS N l=0.18u w=0.82u
M35 VDD net131 s VDD P l=0.18u w=1.24u
M36 Q s VSS VSS N l=0.18u w=0.6u
M37 VDD s Q VDD P l=0.18u w=0.9u
M38 c cn VSS VSS N l=0.18u w=0.42u
M39 VDD cn c VDD P l=0.18u w=0.56u
M40 cn CK VSS VSS N l=0.18u w=0.6u
M41 VDD CK cn VDD P l=0.18u w=0.9u
M42 net164 SI VSS VSS N l=0.18u w=0.3u
M43 VDD SI net164 VDD P l=0.18u w=0.42u
M44 net166 net168 VSS VSS N l=0.18u w=0.3u
M45 VDD net168 net166 VDD P l=0.18u w=0.42u
M46 net168 SE VSS VSS N l=0.18u w=0.3u
M47 VDD SE net168 VDD P l=0.18u w=0.42u
M48 net170 net172 VSS VSS N l=0.18u w=0.3u
M49 VDD net172 net170 VDD P l=0.18u w=0.44u
M50 net172 E VSS VSS N l=0.18u w=0.3u
M51 VDD E net172 VDD P l=0.18u w=0.44u
M52 net174 D VSS VSS N l=0.18u w=0.48u
M53 VDD D net174 VDD P l=0.18u w=0.72u
.ends SEDFFTRX1
*.SCALE meter
.GLOBAL GND VSS VDD

.subckt SEDFFTRX2 Q QN CK D E RN SE SI
M0 VDD SE hnet33 VDD P l=0.18u w=0.56u
M1 hnet33 RN net91 VDD P l=0.18u w=0.56u
M2 net91 SE VSS VSS N l=0.18u w=0.3u
M3 net91 RN VSS VSS N l=0.18u w=0.3u
M4 hnet39 cn pm VDD P l=0.18u w=0.42u
M5 VDD m hnet39 VDD P l=0.18u w=0.42u
M6 hnet37 m VSS VSS N l=0.18u w=0.3u
M7 pm c hnet37 VSS N l=0.18u w=0.3u
M8 hnet45 c net131 VDD P l=0.18u w=0.3u
M9 VDD s hnet45 VDD P l=0.18u w=0.3u
M10 hnet43 s VSS VSS N l=0.18u w=0.3u
M11 net131 cn hnet43 VSS N l=0.18u w=0.3u
M12 net104 net140 net113 VDD P l=0.18u w=0.66u
M13 net131 cn net152 VDD P l=0.18u w=1.72u
M14 net104 net91 VDD VDD P l=0.18u w=0.66u
M15 net113 c pm VDD P l=0.18u w=0.66u
M16 net140 net168 net164 VDD P l=0.18u w=0.42u
M17 net140 net166 net146 VDD P l=0.18u w=0.72u
M18 net146 net170 s VDD P l=0.18u w=0.72u
M19 net146 net172 net174 VDD P l=0.18u w=0.72u
M20 net128 net91 VSS VSS N l=0.18u w=0.36u
M21 net131 c net152 VSS N l=0.18u w=1.14u
M22 net128 net140 VSS VSS N l=0.18u w=0.36u
M23 pm cn net128 VSS N l=0.18u w=0.36u
M24 net140 net166 net164 VSS N l=0.18u w=0.3u
M25 net140 net168 net146 VSS N l=0.18u w=0.48u
M26 net146 net172 s VSS N l=0.18u w=0.48u
M27 net146 net170 net174 VSS N l=0.18u w=1.18u
M28 QN net131 VSS VSS N l=0.18u w=1.16u
M29 VDD net131 QN VDD P l=0.18u w=1.76u
M30 net152 m VSS VSS N l=0.18u w=1.14u
M31 VDD m net152 VDD P l=0.18u w=1.72u
M32 m pm VSS VSS N l=0.18u w=0.42u
M33 VDD pm m VDD P l=0.18u w=0.6u
M34 s net131 VSS VSS N l=0.18u w=1.06u
M35 VDD net131 s VDD P l=0.18u w=1.6u
M36 Q s VSS VSS N l=0.18u w=1.16u
M37 VDD s Q VDD P l=0.18u w=1.76u
M38 c cn VSS VSS N l=0.18u w=0.38u
M39 VDD cn c VDD P l=0.18u w=0.56u
M40 cn CK VSS VSS N l=0.18u w=0.6u
M41 VDD CK cn VDD P l=0.18u w=0.9u
M42 net164 SI VSS VSS N l=0.18u w=0.3u
M43 VDD SI net164 VDD P l=0.18u w=0.42u
M44 net166 net168 VSS VSS N l=0.18u w=0.3u
M45 VDD net168 net166 VDD P l=0.18u w=0.42u
M46 net168 SE VSS VSS N l=0.18u w=0.3u
M47 VDD SE net168 VDD P l=0.18u w=0.42u
M48 net170 net172 VSS VSS N l=0.18u w=0.3u
M49 VDD net172 net170 VDD P l=0.18u w=0.44u
M50 net172 E VSS VSS N l=0.18u w=0.3u
M51 VDD E net172 VDD P l=0.18u w=0.44u
M52 net174 D VSS VSS N l=0.18u w=0.48u
M53 VDD D net174 VDD P l=0.18u w=0.72u
.ends SEDFFTRX2
*.SCALE meter
.GLOBAL GND VSS VDD

.subckt SEDFFTRX4 Q QN CK D E RN SE SI
M0 VDD SE hnet33 VDD P l=0.18u w=0.56u
M1 hnet33 RN net91 VDD P l=0.18u w=0.56u
M2 net91 SE VSS VSS N l=0.18u w=0.3u
M3 net91 RN VSS VSS N l=0.18u w=0.3u
M4 hnet39 cn pm VDD P l=0.18u w=0.42u
M5 VDD m hnet39 VDD P l=0.18u w=0.42u
M6 hnet37 m VSS VSS N l=0.18u w=0.3u
M7 pm c hnet37 VSS N l=0.18u w=0.3u
M8 hnet45 c net131 VDD P l=0.18u w=0.3u
M9 VDD s hnet45 VDD P l=0.18u w=0.3u
M10 hnet43 s VSS VSS N l=0.18u w=0.3u
M11 net131 cn hnet43 VSS N l=0.18u w=0.3u
M12 net104 net140 net113 VDD P l=0.18u w=0.66u
M13 net131 cn net152 VDD P l=0.18u w=1.72u
M14 net104 net91 VDD VDD P l=0.18u w=0.66u
M15 net113 c pm VDD P l=0.18u w=0.66u
M16 net140 net168 net164 VDD P l=0.18u w=0.42u
M17 net140 net166 net146 VDD P l=0.18u w=0.72u
M18 net146 net170 s VDD P l=0.18u w=0.72u
M19 net146 net172 net174 VDD P l=0.18u w=0.72u
M20 net128 net91 VSS VSS N l=0.18u w=0.36u
M21 net131 c net152 VSS N l=0.18u w=1.14u
M22 net128 net140 VSS VSS N l=0.18u w=0.36u
M23 pm cn net128 VSS N l=0.18u w=0.36u
M24 net140 net166 net164 VSS N l=0.18u w=0.3u
M25 net140 net168 net146 VSS N l=0.18u w=0.48u
M26 net146 net172 s VSS N l=0.18u w=0.48u
M27 net146 net170 net174 VSS N l=0.18u w=1.13u
M28 QN net131 VSS VSS N l=0.18u w=2.42u
M29 VDD net131 QN VDD P l=0.18u w=3.6u
M30 net152 m VSS VSS N l=0.18u w=1.14u
M31 VDD m net152 VDD P l=0.18u w=1.72u
M32 m pm VSS VSS N l=0.18u w=0.42u
M33 VDD pm m VDD P l=0.18u w=0.6u
M34 s net131 VSS VSS N l=0.18u w=1.52u
M35 VDD net131 s VDD P l=0.18u w=2.28u
M36 Q s VSS VSS N l=0.18u w=2.42u
M37 VDD s Q VDD P l=0.18u w=3.6u
M38 c cn VSS VSS N l=0.18u w=0.38u
M39 VDD cn c VDD P l=0.18u w=0.56u
M40 cn CK VSS VSS N l=0.18u w=0.6u
M41 VDD CK cn VDD P l=0.18u w=0.9u
M42 net164 SI VSS VSS N l=0.18u w=0.3u
M43 VDD SI net164 VDD P l=0.18u w=0.42u
M44 net166 net168 VSS VSS N l=0.18u w=0.3u
M45 VDD net168 net166 VDD P l=0.18u w=0.42u
M46 net168 SE VSS VSS N l=0.18u w=0.3u
M47 VDD SE net168 VDD P l=0.18u w=0.42u
M48 net170 net172 VSS VSS N l=0.18u w=0.3u
M49 VDD net172 net170 VDD P l=0.18u w=0.44u
M50 net172 E VSS VSS N l=0.18u w=0.3u
M51 VDD E net172 VDD P l=0.18u w=0.44u
M52 net174 D VSS VSS N l=0.18u w=0.48u
M53 VDD D net174 VDD P l=0.18u w=0.72u
.ends SEDFFTRX4
*.SCALE meter
.GLOBAL GND VSS VDD

.subckt SEDFFTRXL Q QN CK D E RN SE SI
M0 VDD SE hnet33 VDD P l=0.18u w=0.56u
M1 hnet33 RN net91 VDD P l=0.18u w=0.56u
M2 net91 SE VSS VSS N l=0.18u w=0.3u
M3 net91 RN VSS VSS N l=0.18u w=0.3u
M4 hnet39 cn pm VDD P l=0.18u w=0.42u
M5 VDD m hnet39 VDD P l=0.18u w=0.42u
M6 hnet37 m VSS VSS N l=0.18u w=0.3u
M7 pm c hnet37 VSS N l=0.18u w=0.3u
M8 hnet45 c net131 VDD P l=0.18u w=0.3u
M9 VDD s hnet45 VDD P l=0.18u w=0.3u
M10 hnet43 s VSS VSS N l=0.18u w=0.3u
M11 net131 cn hnet43 VSS N l=0.18u w=0.3u
M12 net104 net140 net113 VDD P l=0.18u w=0.66u
M13 net131 cn net152 VDD P l=0.18u w=0.84u
M14 net104 net91 VDD VDD P l=0.18u w=0.66u
M15 net113 c pm VDD P l=0.18u w=0.66u
M16 net140 net168 net164 VDD P l=0.18u w=0.76u
M17 net140 net166 net146 VDD P l=0.18u w=0.76u
M18 net146 net170 s VDD P l=0.18u w=0.84u
M19 net146 net172 net174 VDD P l=0.18u w=0.84u
M20 net128 net91 VSS VSS N l=0.18u w=0.36u
M21 net131 c net152 VSS N l=0.18u w=0.56u
M22 net128 net140 VSS VSS N l=0.18u w=0.36u
M23 pm cn net128 VSS N l=0.18u w=0.36u
M24 net140 net166 net164 VSS N l=0.18u w=0.56u
M25 net140 net168 net146 VSS N l=0.18u w=0.56u
M26 net146 net172 s VSS N l=0.18u w=0.56u
M27 net146 net170 net174 VSS N l=0.18u w=0.52u
M28 QN net131 VSS VSS N l=0.18u w=0.42u
M29 VDD net131 QN VDD P l=0.18u w=0.64u
M30 net152 m VSS VSS N l=0.18u w=0.3u
M31 VDD m net152 VDD P l=0.18u w=0.42u
M32 m pm VSS VSS N l=0.18u w=0.3u
M33 VDD pm m VDD P l=0.18u w=0.42u
M34 s net131 VSS VSS N l=0.18u w=0.3u
M35 VDD net131 s VDD P l=0.18u w=0.42u
M36 Q s VSS VSS N l=0.18u w=0.42u
M37 VDD s Q VDD P l=0.18u w=0.64u
M38 c cn VSS VSS N l=0.18u w=0.3u
M39 VDD cn c VDD P l=0.18u w=0.42u
M40 cn CK VSS VSS N l=0.18u w=0.3u
M41 VDD CK cn VDD P l=0.18u w=0.42u
M42 net164 SI VSS VSS N l=0.18u w=0.3u
M43 VDD SI net164 VDD P l=0.18u w=0.42u
M44 net166 net168 VSS VSS N l=0.18u w=0.3u
M45 VDD net168 net166 VDD P l=0.18u w=0.42u
M46 net168 SE VSS VSS N l=0.18u w=0.3u
M47 VDD SE net168 VDD P l=0.18u w=0.42u
M48 net170 net172 VSS VSS N l=0.18u w=0.3u
M49 VDD net172 net170 VDD P l=0.18u w=0.42u
M50 net172 E VSS VSS N l=0.18u w=0.3u
M51 VDD E net172 VDD P l=0.18u w=0.42u
M52 net174 D VSS VSS N l=0.18u w=0.3u
M53 VDD D net174 VDD P l=0.18u w=0.42u
.ends SEDFFTRXL
*.SCALE meter
.GLOBAL GND VSS VDD

.subckt SEDFFX1 Q QN CK D E SE SI
M0 hnet30 SI VSS VSS N l=0.18u w=0.28u
M1 net71 SE hnet30 VSS N l=0.18u w=0.28u
M2 VDD SI hnet35 VDD P l=0.18u w=0.28u
M3 hnet35 net113 net74 VDD P l=0.18u w=0.28u
M4 net79 net113 VSS VSS N l=0.18u w=0.28u
M5 net82 net115 net79 VSS N l=0.18u w=0.28u
M6 net71 s net82 VSS N l=0.18u w=0.28u
M7 net88 E net79 VSS N l=0.18u w=0.28u
M8 net71 D net88 VSS N l=0.18u w=0.28u
M9 net94 cn net71 VSS N l=0.18u w=0.28u
M10 net102 SE VDD VDD P l=0.18u w=0.32u
M11 net108 E net102 VDD P l=0.18u w=0.28u
M12 net105 net115 net102 VDD P l=0.18u w=0.28u
M13 net74 D net105 VDD P l=0.18u w=0.28u
M14 net74 s net108 VDD P l=0.18u w=0.28u
M15 net94 c net74 VDD P l=0.18u w=0.28u
M16 net113 SE VSS VSS N l=0.18u w=0.28u
M17 VDD SE net113 VDD P l=0.18u w=0.42u
M18 net115 E VSS VSS N l=0.18u w=0.28u
M19 VDD E net115 VDD P l=0.18u w=0.42u
M20 Q net130 VSS VSS N l=0.18u w=0.56u
M21 VDD net130 Q VDD P l=0.18u w=0.82u
M22 QN s VSS VSS N l=0.18u w=0.6u
M23 VDD s QN VDD P l=0.18u w=0.9u
M24 s net130 VSS VSS N l=0.18u w=0.4u
M25 VDD net130 s VDD P l=0.18u w=0.6u
M26 m net94 VSS VSS N l=0.18u w=0.3u
M27 VDD net94 m VDD P l=0.18u w=0.46u
M28 c cn VSS VSS N l=0.18u w=0.28u
M29 VDD cn c VDD P l=0.18u w=0.42u
M30 cn CK VSS VSS N l=0.18u w=0.46u
M31 VDD CK cn VDD P l=0.18u w=0.68u
M32 hnet55 cn net130 VDD P l=0.18u w=1.2u
M33 VDD m hnet55 VDD P l=0.18u w=1.2u
M34 hnet53 m VSS VSS N l=0.18u w=0.8u
M35 net130 c hnet53 VSS N l=0.18u w=0.8u
M36 hnet61 c net130 VDD P l=0.18u w=0.28u
M37 VDD s hnet61 VDD P l=0.18u w=0.28u
M38 hnet59 s VSS VSS N l=0.18u w=0.28u
M39 net130 cn hnet59 VSS N l=0.18u w=0.28u
M40 hnet67 cn net94 VDD P l=0.18u w=0.42u
M41 VDD m hnet67 VDD P l=0.18u w=0.42u
M42 hnet65 m VSS VSS N l=0.18u w=0.28u
M43 net94 c hnet65 VSS N l=0.18u w=0.28u
.ends SEDFFX1
*.SCALE meter
.GLOBAL GND VSS VDD

.subckt SEDFFX2 Q QN CK D E SE SI
M0 hnet30 SI VSS VSS N l=0.18u w=0.32u
M1 net71 SE hnet30 VSS N l=0.18u w=0.32u
M2 VDD SI hnet35 VDD P l=0.18u w=0.46u
M3 hnet35 net117 net74 VDD P l=0.18u w=0.46u
M4 hnet43 cn net78 VDD P l=0.18u w=1.12u
M5 hnet41 cn net78 VDD P l=0.18u w=1.12u
M6 VDD m hnet43 VDD P l=0.18u w=1.12u
M7 VDD m hnet41 VDD P l=0.18u w=1.12u
M8 hnet37 m VSS VSS N l=0.18u w=0.76u
M9 hnet38 m VSS VSS N l=0.18u w=0.76u
M10 net78 c hnet37 VSS N l=0.18u w=0.76u
M11 net78 c hnet38 VSS N l=0.18u w=0.76u
M12 net83 net117 VSS VSS N l=0.18u w=0.34u
M13 net86 net119 net83 VSS N l=0.18u w=0.32u
M14 net71 s net86 VSS N l=0.18u w=0.32u
M15 net92 E net83 VSS N l=0.18u w=0.32u
M16 net71 D net92 VSS N l=0.18u w=0.32u
M17 net98 cn net71 VSS N l=0.18u w=0.32u
M18 net106 SE VDD VDD P l=0.18u w=0.56u
M19 net112 E net106 VDD P l=0.18u w=0.46u
M20 net109 net119 net106 VDD P l=0.18u w=0.46u
M21 net74 D net109 VDD P l=0.18u w=0.46u
M22 net74 s net112 VDD P l=0.18u w=0.46u
M23 net98 c net74 VDD P l=0.18u w=0.46u
M24 net117 SE VSS VSS N l=0.18u w=0.28u
M25 VDD SE net117 VDD P l=0.18u w=0.42u
M26 net119 E VSS VSS N l=0.18u w=0.28u
M27 VDD E net119 VDD P l=0.18u w=0.42u
M28 Q net78 VSS VSS N l=0.18u w=1.17u
M29 VDD net78 Q VDD P l=0.18u w=1.76u
M30 QN s VSS VSS N l=0.18u w=1.17u
M31 VDD s QN VDD P l=0.18u w=1.76u
M32 s net78 VSS VSS N l=0.18u w=0.68u
M33 VDD net78 s VDD P l=0.18u w=1.02u
M34 m net98 VSS VSS N l=0.18u w=0.5u
M35 VDD net98 m VDD P l=0.18u w=0.76u
M36 c cn VSS VSS N l=0.18u w=0.4u
M37 VDD cn c VDD P l=0.18u w=0.6u
M38 cn CK VSS VSS N l=0.18u w=0.68u
M39 VDD CK cn VDD P l=0.18u w=1.02u
M40 hnet63 c net78 VDD P l=0.18u w=0.28u
M41 VDD s hnet63 VDD P l=0.18u w=0.28u
M42 hnet61 s VSS VSS N l=0.18u w=0.28u
M43 net78 cn hnet61 VSS N l=0.18u w=0.28u
M44 hnet69 cn net98 VDD P l=0.18u w=0.42u
M45 VDD m hnet69 VDD P l=0.18u w=0.42u
M46 hnet67 m VSS VSS N l=0.18u w=0.28u
M47 net98 c hnet67 VSS N l=0.18u w=0.28u
.ends SEDFFX2
*.SCALE meter
.GLOBAL GND VSS VDD

.subckt SEDFFX4 Q QN CK D E SE SI
M0 hnet30 m VSS VSS N l=0.18u w=0.84u
M1 net85 c hnet30 VSS N l=0.18u w=0.84u
M2 hnet34 m VSS VSS N l=0.18u w=0.92u
M3 net85 c hnet34 VSS N l=0.18u w=0.92u
M4 hnet38 m VSS VSS N l=0.18u w=0.84u
M5 net85 c hnet38 VSS N l=0.18u w=0.84u
M6 hnet42 SI VSS VSS N l=0.18u w=0.56u
M7 net88 SE hnet42 VSS N l=0.18u w=0.56u
M8 VDD m hnet47 VDD P l=0.18u w=1.3u
M9 hnet47 cn net85 VDD P l=0.18u w=1.3u
M10 VDD m hnet51 VDD P l=0.18u w=1.3u
M11 hnet51 cn net85 VDD P l=0.18u w=1.3u
M12 VDD m hnet55 VDD P l=0.18u w=1.4u
M13 hnet55 cn net85 VDD P l=0.18u w=1.4u
M14 VDD SI hnet59 VDD P l=0.18u w=0.82u
M15 hnet59 net139 net100 VDD P l=0.18u w=0.82u
M16 net105 net139 VSS VSS N l=0.18u w=0.6u
M17 net108 net141 net105 VSS N l=0.18u w=0.56u
M18 net88 s net108 VSS N l=0.18u w=0.56u
M19 net114 E net105 VSS N l=0.18u w=0.56u
M20 net88 D net114 VSS N l=0.18u w=0.56u
M21 net120 cn net88 VSS N l=0.18u w=0.56u
M22 net100 D net122 VDD P l=0.18u w=0.76u
M23 net131 SE VDD VDD P l=0.18u w=0.94u
M24 net134 E net131 VDD P l=0.18u w=0.82u
M25 net122 net141 net131 VDD P l=0.18u w=0.76u
M26 net100 s net134 VDD P l=0.18u w=0.82u
M27 net120 c net100 VDD P l=0.18u w=0.82u
M28 net139 SE VSS VSS N l=0.18u w=0.28u
M29 VDD SE net139 VDD P l=0.18u w=0.42u
M30 net141 E VSS VSS N l=0.18u w=0.28u
M31 VDD E net141 VDD P l=0.18u w=0.42u
M32 Q net85 VSS VSS N l=0.18u w=2.48u
M33 VDD net85 Q VDD P l=0.18u w=3.6u
M34 QN s VSS VSS N l=0.18u w=2.48u
M35 VDD s QN VDD P l=0.18u w=3.6u
M36 s net85 VSS VSS N l=0.18u w=1.2u
M37 VDD net85 s VDD P l=0.18u w=1.8u
M38 m net120 VSS VSS N l=0.18u w=0.88u
M39 VDD net120 m VDD P l=0.18u w=1.32u
M40 c cn VSS VSS N l=0.18u w=0.68u
M41 VDD cn c VDD P l=0.18u w=1.02u
M42 cn CK VSS VSS N l=0.18u w=1.16u
M43 VDD CK cn VDD P l=0.18u w=1.74u
M44 hnet79 c net85 VDD P l=0.18u w=0.28u
M45 VDD s hnet79 VDD P l=0.18u w=0.28u
M46 hnet77 s VSS VSS N l=0.18u w=0.28u
M47 net85 cn hnet77 VSS N l=0.18u w=0.28u
M48 hnet85 cn net120 VDD P l=0.18u w=0.42u
M49 VDD m hnet85 VDD P l=0.18u w=0.42u
M50 hnet83 m VSS VSS N l=0.18u w=0.28u
M51 net120 c hnet83 VSS N l=0.18u w=0.28u
.ends SEDFFX4
*.SCALE meter
.GLOBAL GND VSS VDD

.subckt SEDFFXL Q QN CK D E SE SI
M0 hnet30 SI VSS VSS N l=0.18u w=0.28u
M1 net71 SE hnet30 VSS N l=0.18u w=0.28u
M2 VDD SI hnet35 VDD P l=0.18u w=0.42u
M3 hnet35 net113 net74 VDD P l=0.18u w=0.42u
M4 net79 net113 VSS VSS N l=0.18u w=0.28u
M5 net82 net115 net79 VSS N l=0.18u w=0.28u
M6 net71 s net82 VSS N l=0.18u w=0.28u
M7 net88 E net79 VSS N l=0.18u w=0.28u
M8 net71 D net88 VSS N l=0.18u w=0.28u
M9 net94 cn net71 VSS N l=0.18u w=0.28u
M10 net102 SE VDD VDD P l=0.18u w=0.42u
M11 net108 E net102 VDD P l=0.18u w=0.42u
M12 net105 net115 net102 VDD P l=0.18u w=0.42u
M13 net74 D net105 VDD P l=0.18u w=0.42u
M14 net74 s net108 VDD P l=0.18u w=0.42u
M15 net94 c net74 VDD P l=0.18u w=0.42u
M16 net113 SE VSS VSS N l=0.18u w=0.28u
M17 VDD SE net113 VDD P l=0.18u w=0.42u
M18 net115 E VSS VSS N l=0.18u w=0.28u
M19 VDD E net115 VDD P l=0.18u w=0.42u
M20 Q net130 VSS VSS N l=0.18u w=0.42u
M21 VDD net130 Q VDD P l=0.18u w=0.64u
M22 QN s VSS VSS N l=0.18u w=0.42u
M23 VDD s QN VDD P l=0.18u w=0.64u
M24 s net130 VSS VSS N l=0.18u w=0.28u
M25 VDD net130 s VDD P l=0.18u w=0.42u
M26 m net94 VSS VSS N l=0.18u w=0.28u
M27 VDD net94 m VDD P l=0.18u w=0.42u
M28 c cn VSS VSS N l=0.18u w=0.28u
M29 VDD cn c VDD P l=0.18u w=0.42u
M30 cn CK VSS VSS N l=0.18u w=0.28u
M31 VDD CK cn VDD P l=0.18u w=0.42u
M32 hnet55 cn net130 VDD P l=0.18u w=0.84u
M33 VDD m hnet55 VDD P l=0.18u w=0.84u
M34 hnet53 m VSS VSS N l=0.18u w=0.56u
M35 net130 c hnet53 VSS N l=0.18u w=0.56u
M36 hnet61 c net130 VDD P l=0.18u w=0.28u
M37 VDD s hnet61 VDD P l=0.18u w=0.28u
M38 hnet59 s VSS VSS N l=0.18u w=0.28u
M39 net130 cn hnet59 VSS N l=0.18u w=0.28u
M40 hnet67 cn net94 VDD P l=0.18u w=0.42u
M41 VDD m hnet67 VDD P l=0.18u w=0.42u
M42 hnet65 m VSS VSS N l=0.18u w=0.28u
M43 net94 c hnet65 VSS N l=0.18u w=0.28u
.ends SEDFFXL
*.SCALE meter
.GLOBAL GND VSS VDD

.subckt TBUFIX1 Y A OE
M0 hnet9 A VSS VSS N l=0.18u w=0.8u
M1 Y OE hnet9 VSS N l=0.18u w=0.8u
M2 VDD A hnet15 VDD P l=0.18u w=1.2u
M3 hnet15 net16 Y VDD P l=0.18u w=1.2u
M4 net16 OE VSS VSS N l=0.18u w=0.3u
M5 VDD OE net16 VDD P l=0.18u w=0.42u
.ends TBUFIX1
*.SCALE meter
.GLOBAL GND VSS VDD

.subckt TBUFIX12 Y A OE
M0 net17 A VSS VSS N l=0.18u w=1.14u
M1 VDD A net17 VDD P l=0.18u w=1.72u
M2 net19 OE VSS VSS N l=0.18u w=0.48u
M3 VDD OE net19 VDD P l=0.18u w=0.72u
M4 net31 net17 VSS VSS N l=0.18u w=2.88u
M5 net31 net19 VSS VSS N l=0.18u w=0.9u
M6 Y net31 VSS VSS N l=0.18u w=7u
M7 net32 OE net31 VSS N l=0.18u w=1.44u
M8 net32 net17 VDD VDD P l=0.18u w=4.26u
M9 net32 OE VDD VDD P l=0.18u w=1.36u
M10 net31 net19 net32 VDD P l=0.18u w=2.16u
M11 Y net32 VDD VDD P l=0.18u w=10.8u
.ends TBUFIX12
*.SCALE meter
.GLOBAL GND VSS VDD

.subckt TBUFIX16 Y A OE
M0 net17 A VSS VSS N l=0.18u w=1.5u
M1 VDD A net17 VDD P l=0.18u w=2.24u
M2 net19 OE VSS VSS N l=0.18u w=0.64u
M3 VDD OE net19 VDD P l=0.18u w=0.96u
M4 net31 net17 VSS VSS N l=0.18u w=3.84u
M5 net31 net19 VSS VSS N l=0.18u w=1.14u
M6 Y net31 VSS VSS N l=0.18u w=9.4u
M7 net32 OE net31 VSS N l=0.18u w=1.9u
M8 net32 net17 VDD VDD P l=0.18u w=5.3u
M9 net32 OE VDD VDD P l=0.18u w=1.7u
M10 net31 net19 net32 VDD P l=0.18u w=2.84u
M11 Y net32 VDD VDD P l=0.18u w=14.4u
.ends TBUFIX16
*.SCALE meter
.GLOBAL GND VSS VDD

.subckt TBUFIX2 Y A OE
M0 hnet12 A VSS VSS N l=0.18u w=0.8u
M1 Y OE hnet12 VSS N l=0.18u w=0.8u
M2 hnet8 A VSS VSS N l=0.18u w=0.8u
M3 Y OE hnet8 VSS N l=0.18u w=0.8u
M4 VDD A hnet18 VDD P l=0.18u w=1.2u
M5 hnet18 net16 Y VDD P l=0.18u w=1.2u
M6 VDD A hnet14 VDD P l=0.18u w=1.2u
M7 hnet14 net16 Y VDD P l=0.18u w=1.2u
M8 net16 OE VSS VSS N l=0.18u w=0.38u
M9 VDD OE net16 VDD P l=0.18u w=0.56u
.ends TBUFIX2
*.SCALE meter
.GLOBAL GND VSS VDD

.subckt TBUFIX20 Y A OE
M0 net17 A VSS VSS N l=0.18u w=1.88u
M1 VDD A net17 VDD P l=0.18u w=2.82u
M2 net19 OE VSS VSS N l=0.18u w=0.8u
M3 VDD OE net19 VDD P l=0.18u w=1.2u
M4 net31 net17 VSS VSS N l=0.18u w=4.76u
M5 net31 net19 VSS VSS N l=0.18u w=1.5u
M6 Y net31 VSS VSS N l=0.18u w=12.2u
M7 net32 OE net31 VSS N l=0.18u w=2.4u
M8 net32 net17 VDD VDD P l=0.18u w=7u
M9 net32 OE VDD VDD P l=0.18u w=2.24u
M10 net31 net19 net32 VDD P l=0.18u w=3.4u
M11 Y net32 VDD VDD P l=0.18u w=17.5u
.ends TBUFIX20
*.SCALE meter
.GLOBAL GND VSS VDD

.subckt TBUFIX3 Y A OE
M0 net17 A VSS VSS N l=0.18u w=0.3u
M1 VDD A net17 VDD P l=0.18u w=0.42u
M2 net19 OE VSS VSS N l=0.18u w=0.3u
M3 VDD OE net19 VDD P l=0.18u w=0.42u
M4 net31 net17 VSS VSS N l=0.18u w=0.72u
M5 net31 net19 VSS VSS N l=0.18u w=0.3u
M6 Y net31 VSS VSS N l=0.18u w=1.88u
M7 net32 OE net31 VSS N l=0.18u w=0.36u
M8 net32 net17 VDD VDD P l=0.18u w=1.08u
M9 net32 OE VDD VDD P l=0.18u w=0.42u
M10 net31 net19 net32 VDD P l=0.18u w=0.54u
M11 Y net32 VDD VDD P l=0.18u w=2.72u
.ends TBUFIX3
*.SCALE meter
.GLOBAL GND VSS VDD

.subckt TBUFIX4 Y A OE
M0 net17 A VSS VSS N l=0.18u w=0.42u
M1 VDD A net17 VDD P l=0.18u w=0.56u
M2 net19 OE VSS VSS N l=0.18u w=0.3u
M3 VDD OE net19 VDD P l=0.18u w=0.42u
M4 Y net31 VSS VSS N l=0.18u w=2.38u
M5 net31 net17 VSS VSS N l=0.18u w=0.96u
M6 net31 net19 VSS VSS N l=0.18u w=0.3u
M7 net32 OE net31 VSS N l=0.18u w=0.46u
M8 net32 net17 VDD VDD P l=0.18u w=1.44u
M9 net32 OE VDD VDD P l=0.18u w=0.44u
M10 net31 net19 net32 VDD P l=0.18u w=0.72u
M11 Y net32 VDD VDD P l=0.18u w=3.42u
.ends TBUFIX4
*.SCALE meter
.GLOBAL GND VSS VDD

.subckt TBUFIX8 Y A OE
M0 net17 A VSS VSS N l=0.18u w=0.76u
M1 VDD A net17 VDD P l=0.18u w=1.14u
M2 net19 OE VSS VSS N l=0.18u w=0.32u
M3 VDD OE net19 VDD P l=0.18u w=0.48u
M4 net31 net17 VSS VSS N l=0.18u w=1.9u
M5 net31 net19 VSS VSS N l=0.18u w=0.56u
M6 Y net31 VSS VSS N l=0.18u w=5.04u
M7 net32 OE net31 VSS N l=0.18u w=0.96u
M8 net32 net17 VDD VDD P l=0.18u w=2.84u
M9 net32 OE VDD VDD P l=0.18u w=0.9u
M10 net31 net19 net32 VDD P l=0.18u w=1.44u
M11 Y net32 VDD VDD P l=0.18u w=6.72u
.ends TBUFIX8
*.SCALE meter
.GLOBAL GND VSS VDD

.subckt TBUFIXL Y A OE
M0 hnet9 A VSS VSS N l=0.18u w=0.82u
M1 Y OE hnet9 VSS N l=0.18u w=0.82u
M2 VDD A hnet15 VDD P l=0.18u w=1.2u
M3 hnet15 net16 Y VDD P l=0.18u w=1.2u
M4 net16 OE VSS VSS N l=0.18u w=0.3u
M5 VDD OE net16 VDD P l=0.18u w=0.42u
.ends TBUFIXL
*.SCALE meter
.GLOBAL GND VSS VDD

.subckt TBUFX1 Y A OE
M0 net16 OE VSS VSS N l=0.18u w=0.3u
M1 VDD OE net16 VDD P l=0.18u w=0.42u
M2 net28 A VSS VSS N l=0.18u w=0.3u
M3 net28 net16 VSS VSS N l=0.18u w=0.3u
M4 Y net28 VSS VSS N l=0.18u w=0.6u
M5 net29 OE net28 VSS N l=0.18u w=0.3u
M6 net29 A VDD VDD P l=0.18u w=0.42u
M7 net29 OE VDD VDD P l=0.18u w=0.42u
M8 net28 net16 net29 VDD P l=0.18u w=0.42u
M9 Y net29 VDD VDD P l=0.18u w=0.9u
.ends TBUFX1
*.SCALE meter
.GLOBAL GND VSS VDD

.subckt TBUFX12 Y A OE
M0 net16 OE VSS VSS N l=0.18u w=0.48u
M1 VDD OE net16 VDD P l=0.18u w=0.72u
M2 net28 A VSS VSS N l=0.18u w=3.18u
M3 net28 net16 VSS VSS N l=0.18u w=0.9u
M4 Y net28 VSS VSS N l=0.18u w=6.6u
M5 net29 OE net28 VSS N l=0.18u w=1.44u
M6 net29 A VDD VDD P l=0.18u w=4.26u
M7 net29 OE VDD VDD P l=0.18u w=1.36u
M8 net28 net16 net29 VDD P l=0.18u w=2.16u
M9 Y net29 VDD VDD P l=0.18u w=10.8u
.ends TBUFX12
*.SCALE meter
.GLOBAL GND VSS VDD

.subckt TBUFX16 Y A OE
M0 net16 OE VSS VSS N l=0.18u w=0.64u
M1 VDD OE net16 VDD P l=0.18u w=0.96u
M2 net28 A VSS VSS N l=0.18u w=3.84u
M3 net28 net16 VSS VSS N l=0.18u w=1.14u
M4 Y net28 VSS VSS N l=0.18u w=8.8u
M5 net29 OE net28 VSS N l=0.18u w=1.92u
M6 net29 A VDD VDD P l=0.18u w=5.3u
M7 net29 OE VDD VDD P l=0.18u w=1.7u
M8 net28 net16 net29 VDD P l=0.18u w=2.54u
M9 Y net29 VDD VDD P l=0.18u w=14.4u
.ends TBUFX16
*.SCALE meter
.GLOBAL GND VSS VDD

.subckt TBUFX2 Y A OE
M0 net16 OE VSS VSS N l=0.18u w=0.3u
M1 VDD OE net16 VDD P l=0.18u w=0.42u
M2 net28 A VSS VSS N l=0.18u w=0.46u
M3 net28 net16 VSS VSS N l=0.18u w=0.3u
M4 Y net28 VSS VSS N l=0.18u w=1.18u
M5 net29 OE net28 VSS N l=0.18u w=0.3u
M6 net29 A VDD VDD P l=0.18u w=0.72u
M7 net29 OE VDD VDD P l=0.18u w=0.42u
M8 net28 net16 net29 VDD P l=0.18u w=0.42u
M9 Y net29 VDD VDD P l=0.18u w=1.7u
.ends TBUFX2
*.SCALE meter
.GLOBAL GND VSS VDD

.subckt TBUFX20 Y A OE
M0 net16 OE VSS VSS N l=0.18u w=0.8u
M1 VDD OE net16 VDD P l=0.18u w=1.2u
M2 net28 A VSS VSS N l=0.18u w=5.12u
M3 net28 net16 VSS VSS N l=0.18u w=1.52u
M4 Y net28 VSS VSS N l=0.18u w=11.4u
M5 net29 OE net28 VSS N l=0.18u w=2.4u
M6 net29 A VDD VDD P l=0.18u w=7u
M7 net29 OE VDD VDD P l=0.18u w=2.24u
M8 net28 net16 net29 VDD P l=0.18u w=3.4u
M9 Y net29 VDD VDD P l=0.18u w=17.5u
.ends TBUFX20
*.SCALE meter
.GLOBAL GND VSS VDD

.subckt TBUFX3 Y A OE
M0 net16 OE VSS VSS N l=0.18u w=0.3u
M1 VDD OE net16 VDD P l=0.18u w=0.42u
M2 net28 A VSS VSS N l=0.18u w=0.72u
M3 net28 net16 VSS VSS N l=0.18u w=0.3u
M4 Y net28 VSS VSS N l=0.18u w=1.88u
M5 net29 OE net28 VSS N l=0.18u w=0.36u
M6 net29 A VDD VDD P l=0.18u w=1.08u
M7 net29 OE VDD VDD P l=0.18u w=0.42u
M8 net28 net16 net29 VDD P l=0.18u w=0.54u
M9 Y net29 VDD VDD P l=0.18u w=2.68u
.ends TBUFX3
*.SCALE meter
.GLOBAL GND VSS VDD

.subckt TBUFX4 Y A OE
M0 net16 OE VSS VSS N l=0.18u w=0.3u
M1 VDD OE net16 VDD P l=0.18u w=0.46u
M2 net28 A VSS VSS N l=0.18u w=0.96u
M3 net28 net16 VSS VSS N l=0.18u w=0.3u
M4 Y net28 VSS VSS N l=0.18u w=2.4u
M5 net29 OE net28 VSS N l=0.18u w=0.48u
M6 net29 A VDD VDD P l=0.18u w=1.44u
M7 net29 OE VDD VDD P l=0.18u w=0.46u
M8 net28 net16 net29 VDD P l=0.18u w=0.72u
M9 Y net29 VDD VDD P l=0.18u w=3.48u
.ends TBUFX4
*.SCALE meter
.GLOBAL GND VSS VDD

.subckt TBUFX8 Y A OE
M0 net16 OE VSS VSS N l=0.18u w=0.32u
M1 VDD OE net16 VDD P l=0.18u w=0.48u
M2 net28 A VSS VSS N l=0.18u w=1.88u
M3 net28 net16 VSS VSS N l=0.18u w=0.6u
M4 Y net28 VSS VSS N l=0.18u w=4.52u
M5 net29 OE net28 VSS N l=0.18u w=0.96u
M6 net29 A VDD VDD P l=0.18u w=2.84u
M7 net29 OE VDD VDD P l=0.18u w=0.9u
M8 net28 net16 net29 VDD P l=0.18u w=1.44u
M9 Y net29 VDD VDD P l=0.18u w=6.96u
.ends TBUFX8
*.SCALE meter
.GLOBAL GND VSS VDD

.subckt TBUFXL Y A OE
M0 net16 OE VSS VSS N l=0.18u w=0.3u
M1 VDD OE net16 VDD P l=0.18u w=0.42u
M2 net28 A VSS VSS N l=0.18u w=0.3u
M3 net28 net16 VSS VSS N l=0.18u w=0.3u
M4 Y net28 VSS VSS N l=0.18u w=0.3u
M5 net29 OE net28 VSS N l=0.18u w=0.3u
M6 net29 A VDD VDD P l=0.18u w=0.42u
M7 net29 OE VDD VDD P l=0.18u w=0.3u
M8 net28 net16 net29 VDD P l=0.18u w=0.42u
M9 Y net29 VDD VDD P l=0.18u w=0.64u
.ends TBUFXL
*.SCALE meter
.GLOBAL GND VSS VDD

.subckt TIEHI Y
M0 net4 net4 VSS VSS N l=0.18u w=0.3u
M1 Y net4 VDD VDD P l=0.18u w=1u
.ends TIEHI
*.SCALE meter
.GLOBAL GND VSS VDD

.subckt TIELO Y
M0 Y net7 VSS VSS N l=0.18u w=0.56u
M1 net7 net7 VDD VDD P l=0.18u w=0.3u
.ends TIELO
*.SCALE meter
.GLOBAL GND VSS VDD

.subckt TLATNRX1 Q QN D GN RN
M0 VDD D hnet20 VDD P l=0.18u w=0.7u
M1 hnet20 cn pm VDD P l=0.18u w=0.7u
M2 hnet25 D VSS VSS N l=0.18u w=0.56u
M3 hnet21 RN hnet25 VSS N l=0.18u w=0.56u
M4 pm c hnet21 VSS N l=0.18u w=0.56u
M5 cn c VSS VSS N l=0.18u w=0.3u
M6 VDD c cn VDD P l=0.18u w=0.46u
M7 c GN VSS VSS N l=0.18u w=0.3u
M8 VDD GN c VDD P l=0.18u w=0.42u
M9 Q pm VSS VSS N l=0.18u w=0.6u
M10 VDD pm Q VDD P l=0.18u w=0.9u
M11 QN m VSS VSS N l=0.18u w=0.6u
M12 VDD m QN VDD P l=0.18u w=0.9u
M13 m pm VSS VSS N l=0.18u w=0.3u
M14 VDD pm m VDD P l=0.18u w=0.46u
M15 net55 RN net53 VSS N l=0.18u w=0.44u
M16 net53 m VSS VSS N l=0.18u w=0.44u
M17 pm cn net55 VSS N l=0.18u w=0.44u
M18 pm c net58 VDD P l=0.18u w=0.56u
M19 net58 m VDD VDD P l=0.18u w=0.56u
M20 pm RN VDD VDD P l=0.18u w=0.42u
.ends TLATNRX1
*.SCALE meter
.GLOBAL GND VSS VDD

.subckt TLATNRX2 Q QN D GN RN
M0 VDD D hnet20 VDD P l=0.18u w=1.3u
M1 hnet20 cn pm VDD P l=0.18u w=1.3u
M2 hnet25 D VSS VSS N l=0.18u w=1.04u
M3 hnet21 RN hnet25 VSS N l=0.18u w=1.04u
M4 pm c hnet21 VSS N l=0.18u w=1.04u
M5 cn c VSS VSS N l=0.18u w=0.3u
M6 VDD c cn VDD P l=0.18u w=0.42u
M7 c GN VSS VSS N l=0.18u w=0.36u
M8 VDD GN c VDD P l=0.18u w=0.54u
M9 Q pm VSS VSS N l=0.18u w=1.2u
M10 VDD pm Q VDD P l=0.18u w=1.76u
M11 QN m VSS VSS N l=0.18u w=1.2u
M12 VDD m QN VDD P l=0.18u w=1.76u
M13 m pm VSS VSS N l=0.18u w=0.44u
M14 VDD pm m VDD P l=0.18u w=0.66u
M15 net55 RN net53 VSS N l=0.18u w=0.44u
M16 net53 m VSS VSS N l=0.18u w=0.44u
M17 pm cn net55 VSS N l=0.18u w=0.44u
M18 pm c net58 VDD P l=0.18u w=0.56u
M19 net58 m VDD VDD P l=0.18u w=0.56u
M20 pm RN VDD VDD P l=0.18u w=0.42u
.ends TLATNRX2
*.SCALE meter
.GLOBAL GND VSS VDD

.subckt TLATNRX4 Q QN D GN RN
M0 VDD D hnet21 VDD P l=0.18u w=1.26u
M1 hnet21 cn pm VDD P l=0.18u w=1.26u
M2 VDD D hnet18 VDD P l=0.18u w=1.26u
M3 hnet18 cn pm VDD P l=0.18u w=1.26u
M4 hnet28 D VSS VSS N l=0.18u w=0.96u
M5 hnet22 RN hnet28 VSS N l=0.18u w=0.96u
M6 pm c hnet22 VSS N l=0.18u w=0.96u
M7 hnet29 D VSS VSS N l=0.18u w=0.96u
M8 hnet24 RN hnet29 VSS N l=0.18u w=0.96u
M9 pm c hnet24 VSS N l=0.18u w=0.96u
M10 cn c VSS VSS N l=0.18u w=0.46u
M11 VDD c cn VDD P l=0.18u w=0.68u
M12 c GN VSS VSS N l=0.18u w=0.58u
M13 VDD GN c VDD P l=0.18u w=0.88u
M14 Q pm VSS VSS N l=0.18u w=2.4u
M15 VDD pm Q VDD P l=0.18u w=3.6u
M16 QN m VSS VSS N l=0.18u w=2.4u
M17 VDD m QN VDD P l=0.18u w=3.6u
M18 m pm VSS VSS N l=0.18u w=0.78u
M19 VDD pm m VDD P l=0.18u w=1.16u
M20 net55 RN net53 VSS N l=0.18u w=0.46u
M21 net53 m VSS VSS N l=0.18u w=0.46u
M22 pm cn net55 VSS N l=0.18u w=0.46u
M23 pm c net58 VDD P l=0.18u w=0.56u
M24 net58 m VDD VDD P l=0.18u w=0.56u
M25 pm RN VDD VDD P l=0.18u w=0.42u
.ends TLATNRX4
*.SCALE meter
.GLOBAL GND VSS VDD

.subckt TLATNRXL Q QN D GN RN
M0 VDD D hnet20 VDD P l=0.18u w=0.56u
M1 hnet20 cn pm VDD P l=0.18u w=0.56u
M2 hnet25 D VSS VSS N l=0.18u w=0.44u
M3 hnet21 RN hnet25 VSS N l=0.18u w=0.44u
M4 pm c hnet21 VSS N l=0.18u w=0.44u
M5 cn c VSS VSS N l=0.18u w=0.3u
M6 VDD c cn VDD P l=0.18u w=0.42u
M7 c GN VSS VSS N l=0.18u w=0.3u
M8 VDD GN c VDD P l=0.18u w=0.42u
M9 Q pm VSS VSS N l=0.18u w=0.42u
M10 VDD pm Q VDD P l=0.18u w=0.64u
M11 QN m VSS VSS N l=0.18u w=0.42u
M12 VDD m QN VDD P l=0.18u w=0.64u
M13 m pm VSS VSS N l=0.18u w=0.3u
M14 VDD pm m VDD P l=0.18u w=0.42u
M15 net55 RN net53 VSS N l=0.18u w=0.44u
M16 net53 m VSS VSS N l=0.18u w=0.44u
M17 pm cn net55 VSS N l=0.18u w=0.44u
M18 pm c net58 VDD P l=0.18u w=0.56u
M19 net58 m VDD VDD P l=0.18u w=0.56u
M20 pm RN VDD VDD P l=0.18u w=0.42u
.ends TLATNRXL
*.SCALE meter
.GLOBAL GND VSS VDD

.subckt TLATNSRX1 Q QN D GN RN SN
M0 VDD D hnet20 VDD P l=0.18u w=0.82u
M1 hnet20 net57 hnet23 VDD P l=0.18u w=0.82u
M2 hnet23 cn pm VDD P l=0.18u w=0.82u
M3 hnet30 D VSS VSS N l=0.18u w=0.56u
M4 hnet26 RN hnet30 VSS N l=0.18u w=0.56u
M5 pm c hnet26 VSS N l=0.18u w=0.56u
M6 VDD RN hnet35 VDD P l=0.18u w=0.7u
M7 hnet35 net57 pm VDD P l=0.18u w=0.7u
M8 QN m VSS VSS N l=0.18u w=0.6u
M9 VDD m QN VDD P l=0.18u w=0.9u
M10 Q pm VSS VSS N l=0.18u w=0.58u
M11 VDD pm Q VDD P l=0.18u w=0.9u
M12 net57 SN VSS VSS N l=0.18u w=0.4u
M13 VDD SN net57 VDD P l=0.18u w=0.6u
M14 cn c VSS VSS N l=0.18u w=0.3u
M15 VDD c cn VDD P l=0.18u w=0.42u
M16 c GN VSS VSS N l=0.18u w=0.4u
M17 VDD GN c VDD P l=0.18u w=0.6u
M18 m pm VSS VSS N l=0.18u w=0.3u
M19 VDD pm m VDD P l=0.18u w=0.42u
M20 net69 net57 net73 VDD P l=0.18u w=0.66u
M21 pm c net69 VDD P l=0.18u w=0.66u
M22 net73 m VDD VDD P l=0.18u w=0.66u
M23 net81 RN net79 VSS N l=0.18u w=0.44u
M24 net79 m VSS VSS N l=0.18u w=0.44u
M25 pm cn net81 VSS N l=0.18u w=0.44u
M26 pm net57 VSS VSS N l=0.18u w=0.34u
.ends TLATNSRX1
*.SCALE meter
.GLOBAL GND VSS VDD

.subckt TLATNSRX2 Q QN D GN RN SN
M0 VDD D hnet20 VDD P l=0.18u w=1.42u
M1 hnet20 net57 hnet23 VDD P l=0.18u w=1.42u
M2 hnet23 cn pm VDD P l=0.18u w=1.42u
M3 hnet30 D VSS VSS N l=0.18u w=0.92u
M4 hnet26 RN hnet30 VSS N l=0.18u w=0.92u
M5 pm c hnet26 VSS N l=0.18u w=0.92u
M6 VDD RN hnet35 VDD P l=0.18u w=1.26u
M7 hnet35 net57 pm VDD P l=0.18u w=1.26u
M8 QN m VSS VSS N l=0.18u w=1.2u
M9 VDD m QN VDD P l=0.18u w=1.76u
M10 Q pm VSS VSS N l=0.18u w=1.2u
M11 VDD pm Q VDD P l=0.18u w=1.76u
M12 net57 SN VSS VSS N l=0.18u w=0.66u
M13 VDD SN net57 VDD P l=0.18u w=1u
M14 cn c VSS VSS N l=0.18u w=0.3u
M15 VDD c cn VDD P l=0.18u w=0.46u
M16 c GN VSS VSS N l=0.18u w=0.42u
M17 VDD GN c VDD P l=0.18u w=0.64u
M18 m pm VSS VSS N l=0.18u w=0.46u
M19 VDD pm m VDD P l=0.18u w=0.68u
M20 net69 net57 net73 VDD P l=0.18u w=0.66u
M21 pm c net69 VDD P l=0.18u w=0.66u
M22 net73 m VDD VDD P l=0.18u w=0.66u
M23 net81 RN net75 VSS N l=0.18u w=0.44u
M24 net75 m VSS VSS N l=0.18u w=0.44u
M25 pm cn net81 VSS N l=0.18u w=0.44u
M26 pm net57 VSS VSS N l=0.18u w=0.66u
.ends TLATNSRX2
*.SCALE meter
.GLOBAL GND VSS VDD

.subckt TLATNSRX4 Q QN D GN RN SN
M0 VDD D hnet20 VDD P l=0.18u w=1.42u
M1 hnet20 net57 hnet21 VDD P l=0.18u w=1.42u
M2 hnet21 cn pm VDD P l=0.18u w=1.42u
M3 VDD D hnet23 VDD P l=0.18u w=1.42u
M4 hnet23 net57 hnet24 VDD P l=0.18u w=1.42u
M5 hnet24 cn pm VDD P l=0.18u w=1.42u
M6 hnet34 D VSS VSS N l=0.18u w=0.92u
M7 hnet28 RN hnet34 VSS N l=0.18u w=0.92u
M8 pm c hnet28 VSS N l=0.18u w=0.92u
M9 hnet35 D VSS VSS N l=0.18u w=0.92u
M10 hnet30 RN hnet35 VSS N l=0.18u w=0.92u
M11 pm c hnet30 VSS N l=0.18u w=0.92u
M12 VDD RN hnet40 VDD P l=0.18u w=1.26u
M13 hnet40 net57 pm VDD P l=0.18u w=1.26u
M14 VDD RN hnet37 VDD P l=0.18u w=1.26u
M15 hnet37 net57 pm VDD P l=0.18u w=1.26u
M16 QN m VSS VSS N l=0.18u w=2.4u
M17 VDD m QN VDD P l=0.18u w=3.6u
M18 Q pm VSS VSS N l=0.18u w=2.4u
M19 VDD pm Q VDD P l=0.18u w=3.6u
M20 net57 SN VSS VSS N l=0.18u w=1.18u
M21 VDD SN net57 VDD P l=0.18u w=1.76u
M22 cn c VSS VSS N l=0.18u w=0.48u
M23 VDD c cn VDD P l=0.18u w=0.72u
M24 c GN VSS VSS N l=0.18u w=0.68u
M25 VDD GN c VDD P l=0.18u w=1.02u
M26 m pm VSS VSS N l=0.18u w=0.78u
M27 VDD pm m VDD P l=0.18u w=1.16u
M28 net69 net57 net73 VDD P l=0.18u w=0.66u
M29 pm c net69 VDD P l=0.18u w=0.66u
M30 net73 m VDD VDD P l=0.18u w=0.66u
M31 net81 RN net79 VSS N l=0.18u w=0.44u
M32 net79 m VSS VSS N l=0.18u w=0.44u
M33 pm cn net81 VSS N l=0.18u w=0.44u
M34 pm net57 VSS VSS N l=0.18u w=1.26u
.ends TLATNSRX4
*.SCALE meter
.GLOBAL GND VSS VDD

.subckt TLATNSRXL Q QN D GN RN SN
M0 VDD D hnet20 VDD P l=0.18u w=0.66u
M1 hnet20 net57 hnet23 VDD P l=0.18u w=0.66u
M2 hnet23 cn pm VDD P l=0.18u w=0.66u
M3 hnet30 D VSS VSS N l=0.18u w=0.44u
M4 hnet26 RN hnet30 VSS N l=0.18u w=0.44u
M5 pm c hnet26 VSS N l=0.18u w=0.44u
M6 VDD RN hnet35 VDD P l=0.18u w=0.56u
M7 hnet35 net57 pm VDD P l=0.18u w=0.56u
M8 QN m VSS VSS N l=0.18u w=0.42u
M9 VDD m QN VDD P l=0.18u w=0.64u
M10 Q pm VSS VSS N l=0.18u w=0.42u
M11 VDD pm Q VDD P l=0.18u w=0.64u
M12 net57 SN VSS VSS N l=0.18u w=0.3u
M13 VDD SN net57 VDD P l=0.18u w=0.42u
M14 cn c VSS VSS N l=0.18u w=0.3u
M15 VDD c cn VDD P l=0.18u w=0.42u
M16 c GN VSS VSS N l=0.18u w=0.3u
M17 VDD GN c VDD P l=0.18u w=0.42u
M18 m pm VSS VSS N l=0.18u w=0.3u
M19 VDD pm m VDD P l=0.18u w=0.42u
M20 net69 net57 net73 VDD P l=0.18u w=0.66u
M21 pm c net69 VDD P l=0.18u w=0.66u
M22 net73 m VDD VDD P l=0.18u w=0.66u
M23 net81 RN net79 VSS N l=0.18u w=0.44u
M24 net79 m VSS VSS N l=0.18u w=0.44u
M25 pm cn net81 VSS N l=0.18u w=0.44u
M26 pm net57 VSS VSS N l=0.18u w=0.3u
.ends TLATNSRXL
*.SCALE meter
.GLOBAL GND VSS VDD

.subckt TLATNSX1 Q QN D GN SN
M0 VDD D hnet18 VDD P l=0.18u w=0.82u
M1 hnet18 net47 hnet21 VDD P l=0.18u w=0.82u
M2 hnet21 cn pm VDD P l=0.18u w=0.82u
M3 hnet26 D VSS VSS N l=0.18u w=0.46u
M4 pm c hnet26 VSS N l=0.18u w=0.46u
M5 QN m VSS VSS N l=0.18u w=0.6u
M6 VDD m QN VDD P l=0.18u w=0.9u
M7 Q pm VSS VSS N l=0.18u w=0.58u
M8 VDD pm Q VDD P l=0.18u w=0.9u
M9 m pm VSS VSS N l=0.18u w=0.3u
M10 VDD pm m VDD P l=0.18u w=0.42u
M11 net47 SN VSS VSS N l=0.18u w=0.3u
M12 VDD SN net47 VDD P l=0.18u w=0.42u
M13 cn c VSS VSS N l=0.18u w=0.3u
M14 VDD c cn VDD P l=0.18u w=0.42u
M15 c GN VSS VSS N l=0.18u w=0.4u
M16 VDD GN c VDD P l=0.18u w=0.6u
M17 net57 net47 net61 VDD P l=0.18u w=0.66u
M18 pm c net57 VDD P l=0.18u w=0.66u
M19 net61 m VDD VDD P l=0.18u w=0.66u
M20 net66 m VSS VSS N l=0.18u w=0.36u
M21 pm cn net66 VSS N l=0.18u w=0.36u
M22 pm net47 VSS VSS N l=0.18u w=0.3u
.ends TLATNSX1
*.SCALE meter
.GLOBAL GND VSS VDD

.subckt TLATNSX2 Q QN D GN SN
M0 VDD D hnet18 VDD P l=0.18u w=1.42u
M1 hnet18 net47 hnet21 VDD P l=0.18u w=1.42u
M2 hnet21 cn pm VDD P l=0.18u w=1.42u
M3 hnet26 D VSS VSS N l=0.18u w=0.86u
M4 pm c hnet26 VSS N l=0.18u w=0.86u
M5 QN m VSS VSS N l=0.18u w=1.2u
M6 VDD m QN VDD P l=0.18u w=1.76u
M7 Q pm VSS VSS N l=0.18u w=1.2u
M8 VDD pm Q VDD P l=0.18u w=1.76u
M9 m pm VSS VSS N l=0.18u w=0.46u
M10 VDD pm m VDD P l=0.18u w=0.66u
M11 net47 SN VSS VSS N l=0.18u w=0.4u
M12 VDD SN net47 VDD P l=0.18u w=0.6u
M13 cn c VSS VSS N l=0.18u w=0.3u
M14 VDD c cn VDD P l=0.18u w=0.46u
M15 c GN VSS VSS N l=0.18u w=0.4u
M16 VDD GN c VDD P l=0.18u w=0.6u
M17 net57 net47 net61 VDD P l=0.18u w=0.66u
M18 pm c net57 VDD P l=0.18u w=0.66u
M19 net61 m VDD VDD P l=0.18u w=0.66u
M20 net66 m VSS VSS N l=0.18u w=0.36u
M21 pm cn net66 VSS N l=0.18u w=0.36u
M22 pm net47 VSS VSS N l=0.18u w=0.3u
.ends TLATNSX2
*.SCALE meter
.GLOBAL GND VSS VDD

.subckt TLATNSX4 Q QN D GN SN
M0 VDD D hnet18 VDD P l=0.18u w=1.3u
M1 hnet18 net47 hnet19 VDD P l=0.18u w=1.3u
M2 hnet19 cn pm VDD P l=0.18u w=1.3u
M3 VDD D hnet21 VDD P l=0.18u w=1.3u
M4 hnet21 net47 hnet22 VDD P l=0.18u w=1.3u
M5 hnet22 cn pm VDD P l=0.18u w=1.3u
M6 hnet30 D VSS VSS N l=0.18u w=0.74u
M7 pm c hnet30 VSS N l=0.18u w=0.74u
M8 hnet27 D VSS VSS N l=0.18u w=0.74u
M9 pm c hnet27 VSS N l=0.18u w=0.74u
M10 QN m VSS VSS N l=0.18u w=2.4u
M11 VDD m QN VDD P l=0.18u w=3.6u
M12 Q pm VSS VSS N l=0.18u w=2.4u
M13 VDD pm Q VDD P l=0.18u w=3.6u
M14 m pm VSS VSS N l=0.18u w=0.78u
M15 VDD pm m VDD P l=0.18u w=1.16u
M16 net47 SN VSS VSS N l=0.18u w=0.62u
M17 VDD SN net47 VDD P l=0.18u w=0.92u
M18 cn c VSS VSS N l=0.18u w=0.46u
M19 VDD c cn VDD P l=0.18u w=0.66u
M20 c GN VSS VSS N l=0.18u w=0.62u
M21 VDD GN c VDD P l=0.18u w=0.92u
M22 net57 net47 net61 VDD P l=0.18u w=0.66u
M23 pm c net57 VDD P l=0.18u w=0.66u
M24 net61 m VDD VDD P l=0.18u w=0.66u
M25 net66 m VSS VSS N l=0.18u w=0.36u
M26 pm cn net66 VSS N l=0.18u w=0.36u
M27 pm net47 VSS VSS N l=0.18u w=0.3u
.ends TLATNSX4
*.SCALE meter
.GLOBAL GND VSS VDD

.subckt TLATNSXL Q QN D GN SN
M0 VDD D hnet18 VDD P l=0.18u w=0.66u
M1 hnet18 net47 hnet21 VDD P l=0.18u w=0.66u
M2 hnet21 cn pm VDD P l=0.18u w=0.66u
M3 hnet26 D VSS VSS N l=0.18u w=0.36u
M4 pm c hnet26 VSS N l=0.18u w=0.36u
M5 QN m VSS VSS N l=0.18u w=0.46u
M6 VDD m QN VDD P l=0.18u w=0.64u
M7 Q pm VSS VSS N l=0.18u w=0.46u
M8 VDD pm Q VDD P l=0.18u w=0.64u
M9 m pm VSS VSS N l=0.18u w=0.3u
M10 VDD pm m VDD P l=0.18u w=0.42u
M11 net47 SN VSS VSS N l=0.18u w=0.3u
M12 VDD SN net47 VDD P l=0.18u w=0.42u
M13 cn c VSS VSS N l=0.18u w=0.3u
M14 VDD c cn VDD P l=0.18u w=0.46u
M15 c GN VSS VSS N l=0.18u w=0.3u
M16 VDD GN c VDD P l=0.18u w=0.42u
M17 net57 net47 net61 VDD P l=0.18u w=0.66u
M18 pm c net57 VDD P l=0.18u w=0.66u
M19 net61 m VDD VDD P l=0.18u w=0.66u
M20 net66 m VSS VSS N l=0.18u w=0.36u
M21 pm cn net66 VSS N l=0.18u w=0.36u
M22 pm net47 VSS VSS N l=0.18u w=0.3u
.ends TLATNSXL
*.SCALE meter
.GLOBAL GND VSS VDD

.subckt TLATNX1 Q QN D GN
M0 hnet14 cn net22 VDD P l=0.18u w=1.04u
M1 VDD D hnet14 VDD P l=0.18u w=1.04u
M2 hnet12 D VSS VSS N l=0.18u w=0.7u
M3 net22 c hnet12 VSS N l=0.18u w=0.7u
M4 hnet22 c net22 VDD P l=0.18u w=0.42u
M5 VDD m hnet22 VDD P l=0.18u w=0.42u
M6 hnet20 m VSS VSS N l=0.18u w=0.3u
M7 net22 cn hnet20 VSS N l=0.18u w=0.3u
M8 cn c VSS VSS N l=0.18u w=0.3u
M9 VDD c cn VDD P l=0.18u w=0.46u
M10 c GN VSS VSS N l=0.18u w=0.4u
M11 VDD GN c VDD P l=0.18u w=0.6u
M12 Q net22 VSS VSS N l=0.18u w=0.6u
M13 VDD net22 Q VDD P l=0.18u w=0.9u
M14 QN m VSS VSS N l=0.18u w=0.6u
M15 VDD m QN VDD P l=0.18u w=0.9u
M16 m net22 VSS VSS N l=0.18u w=0.3u
M17 VDD net22 m VDD P l=0.18u w=0.46u
.ends TLATNX1
*.SCALE meter
.GLOBAL GND VSS VDD

.subckt TLATNX2 Q QN D GN
M0 hnet14 cn net22 VDD P l=0.18u w=1.7u
M1 VDD D hnet14 VDD P l=0.18u w=1.7u
M2 hnet12 D VSS VSS N l=0.18u w=1.14u
M3 net22 c hnet12 VSS N l=0.18u w=1.14u
M4 hnet22 c net22 VDD P l=0.18u w=0.42u
M5 VDD m hnet22 VDD P l=0.18u w=0.42u
M6 hnet20 m VSS VSS N l=0.18u w=0.3u
M7 net22 cn hnet20 VSS N l=0.18u w=0.3u
M8 cn c VSS VSS N l=0.18u w=0.3u
M9 VDD c cn VDD P l=0.18u w=0.44u
M10 c GN VSS VSS N l=0.18u w=0.42u
M11 VDD GN c VDD P l=0.18u w=0.64u
M12 Q net22 VSS VSS N l=0.18u w=1.2u
M13 VDD net22 Q VDD P l=0.18u w=1.76u
M14 QN m VSS VSS N l=0.18u w=1.2u
M15 VDD m QN VDD P l=0.18u w=1.76u
M16 m net22 VSS VSS N l=0.18u w=0.42u
M17 VDD net22 m VDD P l=0.18u w=0.64u
.ends TLATNX2
*.SCALE meter
.GLOBAL GND VSS VDD

.subckt TLATNX4 Q QN D GN
M0 hnet14 cn net22 VDD P l=0.18u w=1.2u
M1 hnet16 cn net22 VDD P l=0.18u w=1.2u
M2 hnet13 cn net22 VDD P l=0.18u w=1.2u
M3 VDD D hnet14 VDD P l=0.18u w=1.2u
M4 VDD D hnet16 VDD P l=0.18u w=1.2u
M5 VDD D hnet13 VDD P l=0.18u w=1.2u
M6 hnet12 D VSS VSS N l=0.18u w=0.8u
M7 hnet15 D VSS VSS N l=0.18u w=0.8u
M8 hnet20 D VSS VSS N l=0.18u w=0.8u
M9 net22 c hnet12 VSS N l=0.18u w=0.8u
M10 net22 c hnet15 VSS N l=0.18u w=0.8u
M11 net22 c hnet20 VSS N l=0.18u w=0.8u
M12 hnet26 c net22 VDD P l=0.18u w=0.42u
M13 VDD m hnet26 VDD P l=0.18u w=0.42u
M14 hnet24 m VSS VSS N l=0.18u w=0.3u
M15 net22 cn hnet24 VSS N l=0.18u w=0.3u
M16 cn c VSS VSS N l=0.18u w=0.54u
M17 VDD c cn VDD P l=0.18u w=0.8u
M18 c GN VSS VSS N l=0.18u w=0.76u
M19 VDD GN c VDD P l=0.18u w=1.14u
M20 Q net22 VSS VSS N l=0.18u w=2.4u
M21 VDD net22 Q VDD P l=0.18u w=3.48u
M22 QN m VSS VSS N l=0.18u w=2.4u
M23 VDD m QN VDD P l=0.18u w=3.48u
M24 m net22 VSS VSS N l=0.18u w=0.72u
M25 VDD net22 m VDD P l=0.18u w=1.12u
.ends TLATNX4
*.SCALE meter
.GLOBAL GND VSS VDD

.subckt TLATNXL Q QN D GN
M0 hnet14 cn net22 VDD P l=0.18u w=0.84u
M1 VDD D hnet14 VDD P l=0.18u w=0.84u
M2 hnet12 D VSS VSS N l=0.18u w=0.56u
M3 net22 c hnet12 VSS N l=0.18u w=0.56u
M4 hnet22 c net22 VDD P l=0.18u w=0.42u
M5 VDD m hnet22 VDD P l=0.18u w=0.42u
M6 hnet20 m VSS VSS N l=0.18u w=0.3u
M7 net22 cn hnet20 VSS N l=0.18u w=0.3u
M8 cn c VSS VSS N l=0.18u w=0.3u
M9 VDD c cn VDD P l=0.18u w=0.42u
M10 c GN VSS VSS N l=0.18u w=0.3u
M11 VDD GN c VDD P l=0.18u w=0.42u
M12 Q net22 VSS VSS N l=0.18u w=0.42u
M13 VDD net22 Q VDD P l=0.18u w=0.64u
M14 QN m VSS VSS N l=0.18u w=0.42u
M15 VDD m QN VDD P l=0.18u w=0.64u
M16 m net22 VSS VSS N l=0.18u w=0.3u
M17 VDD net22 m VDD P l=0.18u w=0.42u
.ends TLATNXL
*.SCALE meter
.GLOBAL GND VSS VDD

.subckt TLATRX1 Q QN D G RN
M0 VDD D hnet20 VDD P l=0.18u w=0.7u
M1 hnet20 cn pm VDD P l=0.18u w=0.7u
M2 hnet25 D VSS VSS N l=0.18u w=0.56u
M3 hnet21 RN hnet25 VSS N l=0.18u w=0.56u
M4 pm c hnet21 VSS N l=0.18u w=0.56u
M5 c cn VSS VSS N l=0.18u w=0.3u
M6 VDD cn c VDD P l=0.18u w=0.46u
M7 cn G VSS VSS N l=0.18u w=0.3u
M8 VDD G cn VDD P l=0.18u w=0.46u
M9 Q pm VSS VSS N l=0.18u w=0.6u
M10 VDD pm Q VDD P l=0.18u w=0.9u
M11 QN m VSS VSS N l=0.18u w=0.6u
M12 VDD m QN VDD P l=0.18u w=0.9u
M13 m pm VSS VSS N l=0.18u w=0.3u
M14 VDD pm m VDD P l=0.18u w=0.46u
M15 net54 RN net52 VSS N l=0.18u w=0.44u
M16 net52 m VSS VSS N l=0.18u w=0.44u
M17 pm cn net54 VSS N l=0.18u w=0.44u
M18 pm c net57 VDD P l=0.18u w=0.56u
M19 net57 m VDD VDD P l=0.18u w=0.56u
M20 pm RN VDD VDD P l=0.18u w=0.42u
.ends TLATRX1
*.SCALE meter
.GLOBAL GND VSS VDD

.subckt TLATRX2 Q QN D G RN
M0 VDD D hnet20 VDD P l=0.18u w=1.3u
M1 hnet20 cn pm VDD P l=0.18u w=1.3u
M2 hnet25 D VSS VSS N l=0.18u w=1.04u
M3 hnet21 RN hnet25 VSS N l=0.18u w=1.04u
M4 pm c hnet21 VSS N l=0.18u w=1.04u
M5 c cn VSS VSS N l=0.18u w=0.3u
M6 VDD cn c VDD P l=0.18u w=0.42u
M7 cn G VSS VSS N l=0.18u w=0.38u
M8 VDD G cn VDD P l=0.18u w=0.56u
M9 Q pm VSS VSS N l=0.18u w=1.2u
M10 VDD pm Q VDD P l=0.18u w=1.76u
M11 QN m VSS VSS N l=0.18u w=1.2u
M12 VDD m QN VDD P l=0.18u w=1.76u
M13 m pm VSS VSS N l=0.18u w=0.44u
M14 VDD pm m VDD P l=0.18u w=0.66u
M15 net54 RN net52 VSS N l=0.18u w=0.44u
M16 net52 m VSS VSS N l=0.18u w=0.44u
M17 pm cn net54 VSS N l=0.18u w=0.44u
M18 pm c net57 VDD P l=0.18u w=0.56u
M19 net57 m VDD VDD P l=0.18u w=0.56u
M20 pm RN VDD VDD P l=0.18u w=0.42u
.ends TLATRX2
*.SCALE meter
.GLOBAL GND VSS VDD

.subckt TLATRX4 Q QN D G RN
M0 VDD D hnet21 VDD P l=0.18u w=1.26u
M1 hnet21 cn pm VDD P l=0.18u w=1.26u
M2 VDD D hnet18 VDD P l=0.18u w=1.26u
M3 hnet18 cn pm VDD P l=0.18u w=1.26u
M4 hnet28 D VSS VSS N l=0.18u w=0.96u
M5 hnet22 RN hnet28 VSS N l=0.18u w=0.96u
M6 pm c hnet22 VSS N l=0.18u w=0.96u
M7 hnet29 D VSS VSS N l=0.18u w=0.96u
M8 hnet24 RN hnet29 VSS N l=0.18u w=0.96u
M9 pm c hnet24 VSS N l=0.18u w=0.96u
M10 c cn VSS VSS N l=0.18u w=0.4u
M11 VDD cn c VDD P l=0.18u w=0.6u
M12 cn G VSS VSS N l=0.18u w=0.62u
M13 VDD G cn VDD P l=0.18u w=0.92u
M14 Q pm VSS VSS N l=0.18u w=2.4u
M15 VDD pm Q VDD P l=0.18u w=3.6u
M16 QN m VSS VSS N l=0.18u w=2.4u
M17 VDD m QN VDD P l=0.18u w=3.6u
M18 m pm VSS VSS N l=0.18u w=0.78u
M19 VDD pm m VDD P l=0.18u w=1.16u
M20 net54 RN net52 VSS N l=0.18u w=0.46u
M21 net52 m VSS VSS N l=0.18u w=0.46u
M22 pm cn net54 VSS N l=0.18u w=0.46u
M23 pm c net57 VDD P l=0.18u w=0.56u
M24 net57 m VDD VDD P l=0.18u w=0.56u
M25 pm RN VDD VDD P l=0.18u w=0.42u
.ends TLATRX4
*.SCALE meter
.GLOBAL GND VSS VDD

.subckt TLATRXL Q QN D G RN
M0 VDD D hnet20 VDD P l=0.18u w=0.56u
M1 hnet20 cn pm VDD P l=0.18u w=0.56u
M2 hnet25 D VSS VSS N l=0.18u w=0.44u
M3 hnet21 RN hnet25 VSS N l=0.18u w=0.44u
M4 pm c hnet21 VSS N l=0.18u w=0.44u
M5 c cn VSS VSS N l=0.18u w=0.3u
M6 VDD cn c VDD P l=0.18u w=0.42u
M7 cn G VSS VSS N l=0.18u w=0.3u
M8 VDD G cn VDD P l=0.18u w=0.42u
M9 Q pm VSS VSS N l=0.18u w=0.42u
M10 VDD pm Q VDD P l=0.18u w=0.64u
M11 QN m VSS VSS N l=0.18u w=0.42u
M12 VDD m QN VDD P l=0.18u w=0.64u
M13 m pm VSS VSS N l=0.18u w=0.3u
M14 VDD pm m VDD P l=0.18u w=0.42u
M15 net54 RN net52 VSS N l=0.18u w=0.44u
M16 net52 m VSS VSS N l=0.18u w=0.44u
M17 pm cn net54 VSS N l=0.18u w=0.44u
M18 pm c net57 VDD P l=0.18u w=0.56u
M19 net57 m VDD VDD P l=0.18u w=0.56u
M20 pm RN VDD VDD P l=0.18u w=0.42u
.ends TLATRXL
*.SCALE meter
.GLOBAL GND VSS VDD

.subckt TLATSRX1 Q QN D G RN SN
M0 VDD D hnet20 VDD P l=0.18u w=0.82u
M1 hnet20 net56 hnet23 VDD P l=0.18u w=0.82u
M2 hnet23 cn pm VDD P l=0.18u w=0.82u
M3 hnet30 D VSS VSS N l=0.18u w=0.56u
M4 hnet26 RN hnet30 VSS N l=0.18u w=0.56u
M5 pm c hnet26 VSS N l=0.18u w=0.56u
M6 VDD RN hnet35 VDD P l=0.18u w=0.7u
M7 hnet35 net56 pm VDD P l=0.18u w=0.7u
M8 QN m VSS VSS N l=0.18u w=0.6u
M9 VDD m QN VDD P l=0.18u w=0.9u
M10 Q pm VSS VSS N l=0.18u w=0.58u
M11 VDD pm Q VDD P l=0.18u w=0.9u
M12 net56 SN VSS VSS N l=0.18u w=0.4u
M13 VDD SN net56 VDD P l=0.18u w=0.6u
M14 c cn VSS VSS N l=0.18u w=0.3u
M15 VDD cn c VDD P l=0.18u w=0.42u
M16 cn G VSS VSS N l=0.18u w=0.4u
M17 VDD G cn VDD P l=0.18u w=0.6u
M18 m pm VSS VSS N l=0.18u w=0.3u
M19 VDD pm m VDD P l=0.18u w=0.42u
M20 net68 net56 net72 VDD P l=0.18u w=0.66u
M21 pm c net68 VDD P l=0.18u w=0.66u
M22 net72 m VDD VDD P l=0.18u w=0.66u
M23 net80 RN net78 VSS N l=0.18u w=0.44u
M24 net78 m VSS VSS N l=0.18u w=0.44u
M25 pm cn net80 VSS N l=0.18u w=0.44u
M26 pm net56 VSS VSS N l=0.18u w=0.34u
.ends TLATSRX1
*.SCALE meter
.GLOBAL GND VSS VDD

.subckt TLATSRX2 Q QN D G RN SN
M0 VDD D hnet20 VDD P l=0.18u w=1.42u
M1 hnet20 net56 hnet23 VDD P l=0.18u w=1.42u
M2 hnet23 cn pm VDD P l=0.18u w=1.42u
M3 hnet30 D VSS VSS N l=0.18u w=0.92u
M4 hnet26 RN hnet30 VSS N l=0.18u w=0.92u
M5 pm c hnet26 VSS N l=0.18u w=0.92u
M6 VDD RN hnet35 VDD P l=0.18u w=1.26u
M7 hnet35 net56 pm VDD P l=0.18u w=1.26u
M8 QN m VSS VSS N l=0.18u w=1.2u
M9 VDD m QN VDD P l=0.18u w=1.76u
M10 Q pm VSS VSS N l=0.18u w=1.2u
M11 VDD pm Q VDD P l=0.18u w=1.76u
M12 net56 SN VSS VSS N l=0.18u w=0.66u
M13 VDD SN net56 VDD P l=0.18u w=1u
M14 c cn VSS VSS N l=0.18u w=0.3u
M15 VDD cn c VDD P l=0.18u w=0.46u
M16 cn G VSS VSS N l=0.18u w=0.42u
M17 VDD G cn VDD P l=0.18u w=0.64u
M18 m pm VSS VSS N l=0.18u w=0.46u
M19 VDD pm m VDD P l=0.18u w=0.68u
M20 net68 net56 net72 VDD P l=0.18u w=0.66u
M21 pm c net68 VDD P l=0.18u w=0.66u
M22 net72 m VDD VDD P l=0.18u w=0.66u
M23 net80 RN net74 VSS N l=0.18u w=0.44u
M24 net74 m VSS VSS N l=0.18u w=0.44u
M25 pm cn net80 VSS N l=0.18u w=0.44u
M26 pm net56 VSS VSS N l=0.18u w=0.66u
.ends TLATSRX2
*.SCALE meter
.GLOBAL GND VSS VDD

.subckt TLATSRX4 Q QN D G RN SN
M0 VDD D hnet20 VDD P l=0.18u w=1.42u
M1 hnet20 net56 hnet21 VDD P l=0.18u w=1.42u
M2 hnet21 cn pm VDD P l=0.18u w=1.42u
M3 VDD D hnet23 VDD P l=0.18u w=1.42u
M4 hnet23 net56 hnet24 VDD P l=0.18u w=1.42u
M5 hnet24 cn pm VDD P l=0.18u w=1.42u
M6 hnet34 D VSS VSS N l=0.18u w=0.92u
M7 hnet28 RN hnet34 VSS N l=0.18u w=0.92u
M8 pm c hnet28 VSS N l=0.18u w=0.92u
M9 hnet35 D VSS VSS N l=0.18u w=0.92u
M10 hnet30 RN hnet35 VSS N l=0.18u w=0.92u
M11 pm c hnet30 VSS N l=0.18u w=0.92u
M12 VDD RN hnet40 VDD P l=0.18u w=1.26u
M13 hnet40 net56 pm VDD P l=0.18u w=1.26u
M14 VDD RN hnet37 VDD P l=0.18u w=1.26u
M15 hnet37 net56 pm VDD P l=0.18u w=1.26u
M16 QN m VSS VSS N l=0.18u w=2.4u
M17 VDD m QN VDD P l=0.18u w=3.6u
M18 Q pm VSS VSS N l=0.18u w=2.4u
M19 VDD pm Q VDD P l=0.18u w=3.6u
M20 net56 SN VSS VSS N l=0.18u w=1.18u
M21 VDD SN net56 VDD P l=0.18u w=1.79u
M22 c cn VSS VSS N l=0.18u w=0.48u
M23 VDD cn c VDD P l=0.18u w=0.72u
M24 cn G VSS VSS N l=0.18u w=0.68u
M25 VDD G cn VDD P l=0.18u w=1.02u
M26 m pm VSS VSS N l=0.18u w=0.78u
M27 VDD pm m VDD P l=0.18u w=1.16u
M28 net68 net56 net72 VDD P l=0.18u w=0.66u
M29 pm c net68 VDD P l=0.18u w=0.66u
M30 net72 m VDD VDD P l=0.18u w=0.66u
M31 net80 RN net78 VSS N l=0.18u w=0.44u
M32 net78 m VSS VSS N l=0.18u w=0.44u
M33 pm cn net80 VSS N l=0.18u w=0.44u
M34 pm net56 VSS VSS N l=0.18u w=1.26u
.ends TLATSRX4
*.SCALE meter
.GLOBAL GND VSS VDD

.subckt TLATSRXL Q QN D G RN SN
M0 VDD D hnet20 VDD P l=0.18u w=0.66u
M1 hnet20 net56 hnet23 VDD P l=0.18u w=0.66u
M2 hnet23 cn pm VDD P l=0.18u w=0.66u
M3 hnet30 D VSS VSS N l=0.18u w=0.44u
M4 hnet26 RN hnet30 VSS N l=0.18u w=0.44u
M5 pm c hnet26 VSS N l=0.18u w=0.44u
M6 VDD RN hnet35 VDD P l=0.18u w=0.56u
M7 hnet35 net56 pm VDD P l=0.18u w=0.56u
M8 QN m VSS VSS N l=0.18u w=0.42u
M9 VDD m QN VDD P l=0.18u w=0.64u
M10 Q pm VSS VSS N l=0.18u w=0.42u
M11 VDD pm Q VDD P l=0.18u w=0.64u
M12 net56 SN VSS VSS N l=0.18u w=0.3u
M13 VDD SN net56 VDD P l=0.18u w=0.42u
M14 c cn VSS VSS N l=0.18u w=0.3u
M15 VDD cn c VDD P l=0.18u w=0.42u
M16 cn G VSS VSS N l=0.18u w=0.3u
M17 VDD G cn VDD P l=0.18u w=0.42u
M18 m pm VSS VSS N l=0.18u w=0.3u
M19 VDD pm m VDD P l=0.18u w=0.42u
M20 net68 net56 net72 VDD P l=0.18u w=0.66u
M21 pm c net68 VDD P l=0.18u w=0.66u
M22 net72 m VDD VDD P l=0.18u w=0.66u
M23 net80 RN net78 VSS N l=0.18u w=0.44u
M24 net78 m VSS VSS N l=0.18u w=0.44u
M25 pm cn net80 VSS N l=0.18u w=0.44u
M26 pm net56 VSS VSS N l=0.18u w=0.3u
.ends TLATSRXL
*.SCALE meter
.GLOBAL GND VSS VDD

.subckt TLATSX1 Q QN D G SN
M0 VDD D hnet18 VDD P l=0.18u w=0.82u
M1 hnet18 net46 hnet21 VDD P l=0.18u w=0.82u
M2 hnet21 cn pm VDD P l=0.18u w=0.82u
M3 hnet26 D VSS VSS N l=0.18u w=0.46u
M4 pm c hnet26 VSS N l=0.18u w=0.46u
M5 QN m VSS VSS N l=0.18u w=0.6u
M6 VDD m QN VDD P l=0.18u w=0.9u
M7 Q pm VSS VSS N l=0.18u w=0.56u
M8 VDD pm Q VDD P l=0.18u w=0.9u
M9 m pm VSS VSS N l=0.18u w=0.3u
M10 VDD pm m VDD P l=0.18u w=0.42u
M11 net46 SN VSS VSS N l=0.18u w=0.3u
M12 VDD SN net46 VDD P l=0.18u w=0.42u
M13 c cn VSS VSS N l=0.18u w=0.3u
M14 VDD cn c VDD P l=0.18u w=0.42u
M15 cn G VSS VSS N l=0.18u w=0.4u
M16 VDD G cn VDD P l=0.18u w=0.6u
M17 net56 net46 net60 VDD P l=0.18u w=0.66u
M18 pm c net56 VDD P l=0.18u w=0.66u
M19 net60 m VDD VDD P l=0.18u w=0.66u
M20 net65 m VSS VSS N l=0.18u w=0.36u
M21 pm cn net65 VSS N l=0.18u w=0.36u
M22 pm net46 VSS VSS N l=0.18u w=0.3u
.ends TLATSX1
*.SCALE meter
.GLOBAL GND VSS VDD

.subckt TLATSX2 Q QN D G SN
M0 VDD D hnet18 VDD P l=0.18u w=1.42u
M1 hnet18 net46 hnet21 VDD P l=0.18u w=1.42u
M2 hnet21 cn pm VDD P l=0.18u w=1.42u
M3 hnet26 D VSS VSS N l=0.18u w=0.86u
M4 pm c hnet26 VSS N l=0.18u w=0.86u
M5 QN m VSS VSS N l=0.18u w=1.2u
M6 VDD m QN VDD P l=0.18u w=1.76u
M7 Q pm VSS VSS N l=0.18u w=1.2u
M8 VDD pm Q VDD P l=0.18u w=1.76u
M9 m pm VSS VSS N l=0.18u w=0.46u
M10 VDD pm m VDD P l=0.18u w=0.66u
M11 net46 SN VSS VSS N l=0.18u w=0.4u
M12 VDD SN net46 VDD P l=0.18u w=0.6u
M13 c cn VSS VSS N l=0.18u w=0.3u
M14 VDD cn c VDD P l=0.18u w=0.46u
M15 cn G VSS VSS N l=0.18u w=0.4u
M16 VDD G cn VDD P l=0.18u w=0.6u
M17 net56 net46 net60 VDD P l=0.18u w=0.66u
M18 pm c net56 VDD P l=0.18u w=0.66u
M19 net60 m VDD VDD P l=0.18u w=0.66u
M20 net65 m VSS VSS N l=0.18u w=0.36u
M21 pm cn net65 VSS N l=0.18u w=0.36u
M22 pm net46 VSS VSS N l=0.18u w=0.3u
.ends TLATSX2
*.SCALE meter
.GLOBAL GND VSS VDD

.subckt TLATSX4 Q QN D G SN
M0 VDD D hnet18 VDD P l=0.18u w=1.3u
M1 hnet18 net46 hnet19 VDD P l=0.18u w=1.3u
M2 hnet19 cn pm VDD P l=0.18u w=1.3u
M3 VDD D hnet21 VDD P l=0.18u w=1.3u
M4 hnet21 net46 hnet22 VDD P l=0.18u w=1.3u
M5 hnet22 cn pm VDD P l=0.18u w=1.3u
M6 hnet30 D VSS VSS N l=0.18u w=0.74u
M7 pm c hnet30 VSS N l=0.18u w=0.74u
M8 hnet27 D VSS VSS N l=0.18u w=0.74u
M9 pm c hnet27 VSS N l=0.18u w=0.74u
M10 QN m VSS VSS N l=0.18u w=2.4u
M11 VDD m QN VDD P l=0.18u w=3.6u
M12 Q pm VSS VSS N l=0.18u w=2.4u
M13 VDD pm Q VDD P l=0.18u w=3.6u
M14 m pm VSS VSS N l=0.18u w=0.78u
M15 VDD pm m VDD P l=0.18u w=1.16u
M16 net46 SN VSS VSS N l=0.18u w=0.62u
M17 VDD SN net46 VDD P l=0.18u w=0.92u
M18 c cn VSS VSS N l=0.18u w=0.46u
M19 VDD cn c VDD P l=0.18u w=0.66u
M20 cn G VSS VSS N l=0.18u w=0.62u
M21 VDD G cn VDD P l=0.18u w=0.92u
M22 net56 net46 net60 VDD P l=0.18u w=0.66u
M23 pm c net56 VDD P l=0.18u w=0.66u
M24 net60 m VDD VDD P l=0.18u w=0.66u
M25 net65 m VSS VSS N l=0.18u w=0.36u
M26 pm cn net65 VSS N l=0.18u w=0.36u
M27 pm net46 VSS VSS N l=0.18u w=0.3u
.ends TLATSX4
*.SCALE meter
.GLOBAL GND VSS VDD

.subckt TLATSXL Q QN D G SN
M0 VDD D hnet18 VDD P l=0.18u w=0.66u
M1 hnet18 net46 hnet21 VDD P l=0.18u w=0.66u
M2 hnet21 cn pm VDD P l=0.18u w=0.66u
M3 hnet26 D VSS VSS N l=0.18u w=0.36u
M4 pm c hnet26 VSS N l=0.18u w=0.36u
M5 QN m VSS VSS N l=0.18u w=0.46u
M6 VDD m QN VDD P l=0.18u w=0.64u
M7 Q pm VSS VSS N l=0.18u w=0.46u
M8 VDD pm Q VDD P l=0.18u w=0.64u
M9 m pm VSS VSS N l=0.18u w=0.3u
M10 VDD pm m VDD P l=0.18u w=0.42u
M11 net46 SN VSS VSS N l=0.18u w=0.3u
M12 VDD SN net46 VDD P l=0.18u w=0.42u
M13 c cn VSS VSS N l=0.18u w=0.3u
M14 VDD cn c VDD P l=0.18u w=0.46u
M15 cn G VSS VSS N l=0.18u w=0.3u
M16 VDD G cn VDD P l=0.18u w=0.42u
M17 net56 net46 net60 VDD P l=0.18u w=0.66u
M18 pm c net56 VDD P l=0.18u w=0.66u
M19 net60 m VDD VDD P l=0.18u w=0.66u
M20 net65 m VSS VSS N l=0.18u w=0.36u
M21 pm cn net65 VSS N l=0.18u w=0.36u
M22 pm net46 VSS VSS N l=0.18u w=0.3u
.ends TLATSXL
*.SCALE meter
.GLOBAL GND VSS VDD

.subckt TLATX1 Q QN D G
M0 hnet14 cn pm VDD P l=0.18u w=1.04u
M1 VDD D hnet14 VDD P l=0.18u w=1.04u
M2 hnet12 D VSS VSS N l=0.18u w=0.7u
M3 pm c hnet12 VSS N l=0.18u w=0.7u
M4 hnet22 c pm VDD P l=0.18u w=0.42u
M5 VDD m hnet22 VDD P l=0.18u w=0.42u
M6 hnet20 m VSS VSS N l=0.18u w=0.3u
M7 pm cn hnet20 VSS N l=0.18u w=0.3u
M8 c cn VSS VSS N l=0.18u w=0.3u
M9 VDD cn c VDD P l=0.18u w=0.46u
M10 cn G VSS VSS N l=0.18u w=0.4u
M11 VDD G cn VDD P l=0.18u w=0.6u
M12 Q pm VSS VSS N l=0.18u w=0.6u
M13 VDD pm Q VDD P l=0.18u w=0.9u
M14 QN m VSS VSS N l=0.18u w=0.6u
M15 VDD m QN VDD P l=0.18u w=0.9u
M16 m pm VSS VSS N l=0.18u w=0.3u
M17 VDD pm m VDD P l=0.18u w=0.46u
.ends TLATX1
*.SCALE meter
.GLOBAL GND VSS VDD

.subckt TLATX2 Q QN D G
M0 hnet14 cn pm VDD P l=0.18u w=1.7u
M1 VDD D hnet14 VDD P l=0.18u w=1.7u
M2 hnet12 D VSS VSS N l=0.18u w=1.14u
M3 pm c hnet12 VSS N l=0.18u w=1.14u
M4 hnet22 c pm VDD P l=0.18u w=0.42u
M5 VDD m hnet22 VDD P l=0.18u w=0.42u
M6 hnet20 m VSS VSS N l=0.18u w=0.3u
M7 pm cn hnet20 VSS N l=0.18u w=0.3u
M8 c cn VSS VSS N l=0.18u w=0.3u
M9 VDD cn c VDD P l=0.18u w=0.44u
M10 cn G VSS VSS N l=0.18u w=0.42u
M11 VDD G cn VDD P l=0.18u w=0.64u
M12 Q pm VSS VSS N l=0.18u w=1.2u
M13 VDD pm Q VDD P l=0.18u w=1.74u
M14 QN m VSS VSS N l=0.18u w=1.2u
M15 VDD m QN VDD P l=0.18u w=1.74u
M16 m pm VSS VSS N l=0.18u w=0.42u
M17 VDD pm m VDD P l=0.18u w=0.64u
.ends TLATX2
*.SCALE meter
.GLOBAL GND VSS VDD

.subckt TLATX4 Q QN D G
M0 hnet14 cn pm VDD P l=0.18u w=1.2u
M1 hnet16 cn pm VDD P l=0.18u w=1.2u
M2 hnet13 cn pm VDD P l=0.18u w=1.2u
M3 VDD D hnet14 VDD P l=0.18u w=1.2u
M4 VDD D hnet16 VDD P l=0.18u w=1.2u
M5 VDD D hnet13 VDD P l=0.18u w=1.2u
M6 hnet12 D VSS VSS N l=0.18u w=0.8u
M7 hnet15 D VSS VSS N l=0.18u w=0.8u
M8 hnet20 D VSS VSS N l=0.18u w=0.8u
M9 pm c hnet12 VSS N l=0.18u w=0.8u
M10 pm c hnet15 VSS N l=0.18u w=0.8u
M11 pm c hnet20 VSS N l=0.18u w=0.8u
M12 hnet26 c pm VDD P l=0.18u w=0.42u
M13 VDD m hnet26 VDD P l=0.18u w=0.42u
M14 hnet24 m VSS VSS N l=0.18u w=0.3u
M15 pm cn hnet24 VSS N l=0.18u w=0.3u
M16 c cn VSS VSS N l=0.18u w=0.54u
M17 VDD cn c VDD P l=0.18u w=0.8u
M18 cn G VSS VSS N l=0.18u w=0.76u
M19 VDD G cn VDD P l=0.18u w=1.14u
M20 Q pm VSS VSS N l=0.18u w=2.4u
M21 VDD pm Q VDD P l=0.18u w=3.48u
M22 QN m VSS VSS N l=0.18u w=2.4u
M23 VDD m QN VDD P l=0.18u w=3.48u
M24 m pm VSS VSS N l=0.18u w=0.72u
M25 VDD pm m VDD P l=0.18u w=1.12u
.ends TLATX4
*.SCALE meter
.GLOBAL GND VSS VDD

.subckt TLATXL Q QN D G
M0 hnet14 cn pm VDD P l=0.18u w=0.84u
M1 VDD D hnet14 VDD P l=0.18u w=0.84u
M2 hnet12 D VSS VSS N l=0.18u w=0.56u
M3 pm c hnet12 VSS N l=0.18u w=0.56u
M4 hnet22 c pm VDD P l=0.18u w=0.42u
M5 VDD m hnet22 VDD P l=0.18u w=0.42u
M6 hnet20 m VSS VSS N l=0.18u w=0.3u
M7 pm cn hnet20 VSS N l=0.18u w=0.3u
M8 c cn VSS VSS N l=0.18u w=0.3u
M9 VDD cn c VDD P l=0.18u w=0.42u
M10 cn G VSS VSS N l=0.18u w=0.3u
M11 VDD G cn VDD P l=0.18u w=0.42u
M12 Q pm VSS VSS N l=0.18u w=0.42u
M13 VDD pm Q VDD P l=0.18u w=0.64u
M14 QN m VSS VSS N l=0.18u w=0.42u
M15 VDD m QN VDD P l=0.18u w=0.64u
M16 m pm VSS VSS N l=0.18u w=0.3u
M17 VDD pm m VDD P l=0.18u w=0.42u
.ends TLATXL
*.SCALE meter
.GLOBAL GND VSS VDD

.subckt TTLATX1 Q D G OE
M0 Q OE net51 VSS N l=0.18u w=1.18u
M1 Q net47 net51 VDD P l=0.18u w=1.8u
M2 hnet16 cn pm VDD P l=0.18u w=1.7u
M3 VDD D hnet16 VDD P l=0.18u w=1.7u
M4 hnet14 D VSS VSS N l=0.18u w=1.12u
M5 pm c hnet14 VSS N l=0.18u w=1.12u
M6 hnet24 c pm VDD P l=0.18u w=0.42u
M7 VDD m hnet24 VDD P l=0.18u w=0.42u
M8 hnet22 m VSS VSS N l=0.18u w=0.28u
M9 pm cn hnet22 VSS N l=0.18u w=0.28u
M10 c cn VSS VSS N l=0.18u w=0.28u
M11 VDD cn c VDD P l=0.18u w=0.42u
M12 cn G VSS VSS N l=0.18u w=0.4u
M13 VDD G cn VDD P l=0.18u w=0.6u
M14 net47 OE VSS VSS N l=0.18u w=0.28u
M15 VDD OE net47 VDD P l=0.18u w=0.42u
M16 m pm VSS VSS N l=0.18u w=0.28u
M17 VDD pm m VDD P l=0.18u w=0.42u
M18 net51 pm VSS VSS N l=0.18u w=1.18u
M19 VDD pm net51 VDD P l=0.18u w=1.8u
.ends TTLATX1
*.SCALE meter
.GLOBAL GND VSS VDD

.subckt TTLATX2 Q D G OE
M0 Q OE net51 VSS N l=0.18u w=2.4u
M1 Q net47 net51 VDD P l=0.18u w=3.4u
M2 hnet22 cn pm VDD P l=0.18u w=1.6u
M3 hnet19 cn pm VDD P l=0.18u w=1.6u
M4 VDD D hnet22 VDD P l=0.18u w=1.6u
M5 VDD D hnet19 VDD P l=0.18u w=1.6u
M6 hnet14 D VSS VSS N l=0.18u w=1.06u
M7 hnet15 D VSS VSS N l=0.18u w=1.06u
M8 pm c hnet14 VSS N l=0.18u w=1.06u
M9 pm c hnet15 VSS N l=0.18u w=1.06u
M10 hnet26 c pm VDD P l=0.18u w=0.42u
M11 VDD m hnet26 VDD P l=0.18u w=0.42u
M12 hnet24 m VSS VSS N l=0.18u w=0.28u
M13 pm cn hnet24 VSS N l=0.18u w=0.28u
M14 c cn VSS VSS N l=0.18u w=0.48u
M15 VDD cn c VDD P l=0.18u w=0.72u
M16 cn G VSS VSS N l=0.18u w=0.68u
M17 VDD G cn VDD P l=0.18u w=1.02u
M18 net47 OE VSS VSS N l=0.18u w=0.58u
M19 VDD OE net47 VDD P l=0.18u w=0.88u
M20 m pm VSS VSS N l=0.18u w=0.28u
M21 VDD pm m VDD P l=0.18u w=0.42u
M22 net51 pm VSS VSS N l=0.18u w=2.4u
M23 VDD pm net51 VDD P l=0.18u w=3.4u
.ends TTLATX2
*.SCALE meter
.GLOBAL GND VSS VDD

.subckt TTLATX4 Q D G OE
M0 hnet15 D VSS VSS N l=0.18u w=0.9u
M1 pm c hnet15 VSS N l=0.18u w=0.9u
M2 hnet20 D VSS VSS N l=0.18u w=1.22u
M3 pm c hnet20 VSS N l=0.18u w=1.22u
M4 VDD D hnet28 VDD P l=0.18u w=1.6u
M5 hnet28 cn pm VDD P l=0.18u w=1.6u
M6 VDD D hnet24 VDD P l=0.18u w=1.6u
M7 hnet24 cn pm VDD P l=0.18u w=1.6u
M8 Q OE net60 VSS N l=0.18u w=3.6u
M9 Q net56 net60 VDD P l=0.18u w=6.72u
M10 hnet32 c pm VDD P l=0.18u w=0.42u
M11 VDD m hnet32 VDD P l=0.18u w=0.42u
M12 hnet30 m VSS VSS N l=0.18u w=0.28u
M13 pm cn hnet30 VSS N l=0.18u w=0.28u
M14 c cn VSS VSS N l=0.18u w=0.84u
M15 VDD cn c VDD P l=0.18u w=1.26u
M16 cn G VSS VSS N l=0.18u w=1.18u
M17 VDD G cn VDD P l=0.18u w=1.76u
M18 net56 OE VSS VSS N l=0.18u w=1.14u
M19 VDD OE net56 VDD P l=0.18u w=1.72u
M20 m pm VSS VSS N l=0.18u w=0.28u
M21 VDD pm m VDD P l=0.18u w=0.42u
M22 net60 pm VSS VSS N l=0.18u w=4.8u
M23 VDD pm net60 VDD P l=0.18u w=7.2u
.ends TTLATX4
*.SCALE meter
.GLOBAL GND VSS VDD

.subckt TTLATXL Q D G OE
M0 Q OE net51 VSS N l=0.18u w=0.28u
M1 Q net47 net51 VDD P l=0.18u w=0.42u
M2 hnet16 cn pm VDD P l=0.18u w=0.84u
M3 VDD D hnet16 VDD P l=0.18u w=0.84u
M4 hnet14 D VSS VSS N l=0.18u w=0.56u
M5 pm c hnet14 VSS N l=0.18u w=0.56u
M6 hnet24 c pm VDD P l=0.18u w=0.42u
M7 VDD m hnet24 VDD P l=0.18u w=0.42u
M8 hnet22 m VSS VSS N l=0.18u w=0.28u
M9 pm cn hnet22 VSS N l=0.18u w=0.28u
M10 c cn VSS VSS N l=0.18u w=0.28u
M11 VDD cn c VDD P l=0.18u w=0.42u
M12 cn G VSS VSS N l=0.18u w=0.28u
M13 VDD G cn VDD P l=0.18u w=0.42u
M14 net47 OE VSS VSS N l=0.18u w=0.28u
M15 VDD OE net47 VDD P l=0.18u w=0.42u
M16 m pm VSS VSS N l=0.18u w=0.28u
M17 VDD pm m VDD P l=0.18u w=0.42u
M18 net51 pm VSS VSS N l=0.18u w=0.42u
M19 VDD pm net51 VDD P l=0.18u w=0.64u
.ends TTLATXL
*.SCALE meter
.GLOBAL GND VSS VDD

.subckt XNOR2X1 Y A B
M0 net29 A net37 VDD P l=0.18u w=0.72u
M1 net29 net27 net38 VDD P l=0.18u w=0.72u
M2 net29 net27 net37 VSS N l=0.18u w=0.48u
M3 net29 A net38 VSS N l=0.18u w=0.48u
M4 Y net29 VSS VSS N l=0.18u w=0.6u
M5 VDD net29 Y VDD P l=0.18u w=0.9u
M6 net27 A VSS VSS N l=0.18u w=0.3u
M7 VDD A net27 VDD P l=0.18u w=0.42u
M8 net37 net38 VSS VSS N l=0.18u w=0.48u
M9 VDD net38 net37 VDD P l=0.18u w=0.72u
M10 net38 B VSS VSS N l=0.18u w=1.2u
M11 VDD B net38 VDD P l=0.18u w=1.67u
.ends XNOR2X1
*.SCALE meter
.GLOBAL GND VSS VDD

.subckt XNOR2X2 Y A B
M0 net29 A net37 VDD P l=0.18u w=1.4u
M1 net29 net27 net38 VDD P l=0.18u w=1.4u
M2 net29 net27 net37 VSS N l=0.18u w=0.96u
M3 net29 A net38 VSS N l=0.18u w=0.92u
M4 Y net29 VSS VSS N l=0.18u w=1.2u
M5 VDD net29 Y VDD P l=0.18u w=1.76u
M6 net27 A VSS VSS N l=0.18u w=0.38u
M7 VDD A net27 VDD P l=0.18u w=0.56u
M8 net37 net38 VSS VSS N l=0.18u w=0.96u
M9 VDD net38 net37 VDD P l=0.18u w=1.4u
M10 net38 B VSS VSS N l=0.18u w=2.52u
M11 VDD B net38 VDD P l=0.18u w=3.82u
.ends XNOR2X2
*.SCALE meter
.GLOBAL GND VSS VDD

.subckt XNOR2X4 Y A B
M0 net29 A net37 VDD P l=0.18u w=2.84u
M1 net29 net27 net38 VDD P l=0.18u w=3u
M2 net29 net27 net37 VSS N l=0.18u w=2.18u
M3 net29 A net38 VSS N l=0.18u w=2.1u
M4 Y net29 VSS VSS N l=0.18u w=2.6u
M5 VDD net29 Y VDD P l=0.18u w=3.32u
M6 net27 A VSS VSS N l=0.18u w=0.76u
M7 VDD A net27 VDD P l=0.18u w=1.14u
M8 net37 net38 VSS VSS N l=0.18u w=1.9u
M9 VDD net38 net37 VDD P l=0.18u w=2.84u
M10 net38 B VSS VSS N l=0.18u w=5.04u
M11 VDD B net38 VDD P l=0.18u w=7.2u
.ends XNOR2X4
*.SCALE meter
.GLOBAL GND VSS VDD

.subckt XNOR2XL Y A B
M0 net29 A net37 VDD P l=0.18u w=0.84u
M1 net29 net27 net38 VDD P l=0.18u w=0.84u
M2 net29 net27 net37 VSS N l=0.18u w=0.56u
M3 net29 A net38 VSS N l=0.18u w=0.56u
M4 Y net29 VSS VSS N l=0.18u w=0.42u
M5 VDD net29 Y VDD P l=0.18u w=0.64u
M6 net27 A VSS VSS N l=0.18u w=0.3u
M7 VDD A net27 VDD P l=0.18u w=0.42u
M8 net37 net38 VSS VSS N l=0.18u w=0.3u
M9 VDD net38 net37 VDD P l=0.18u w=0.42u
M10 net38 B VSS VSS N l=0.18u w=0.3u
M11 VDD B net38 VDD P l=0.18u w=0.42u
.ends XNOR2XL
*.SCALE meter
.GLOBAL GND VSS VDD

.subckt XNOR3X2 Y A B C
M0 net54 net62 VSS VSS N l=0.18u w=0.93u
M1 VDD net62 net54 VDD P l=0.18u w=1.4u
M2 Y net93 VSS VSS N l=0.18u w=1.2u
M3 VDD net93 Y VDD P l=0.18u w=1.8u
M4 net91 C VSS VSS N l=0.18u w=0.36u
M5 VDD C net91 VDD P l=0.18u w=0.54u
M6 net60 B VSS VSS N l=0.18u w=0.85u
M7 VDD B net60 VDD P l=0.18u w=1.28u
M8 net62 A VSS VSS N l=0.18u w=1.2u
M9 VDD A net62 VDD P l=0.18u w=1.8u
M10 net87 net60 net62 VDD P l=0.18u w=1.76u
M11 net87 B net54 VDD P l=0.18u w=1.4u
M12 net93 net91 net99 VDD P l=0.18u w=1.4u
M13 net93 C net87 VDD P l=0.18u w=1.4u
M14 net99 B net62 VDD P l=0.18u w=1.76u
M15 net99 net60 net54 VDD P l=0.18u w=1.4u
M16 net87 B net62 VSS N l=0.18u w=1.2u
M17 net87 net60 net54 VSS N l=0.18u w=0.93u
M18 net93 C net99 VSS N l=0.18u w=0.93u
M19 net93 net91 net87 VSS N l=0.18u w=0.93u
M20 net99 net60 net62 VSS N l=0.18u w=1.2u
M21 net99 B net54 VSS N l=0.18u w=0.93u
.ends XNOR3X2
*.SCALE meter
.GLOBAL GND VSS VDD

.subckt XNOR3X4 Y A B C
M0 net54 net62 VSS VSS N l=0.18u w=1.86u
M1 VDD net62 net54 VDD P l=0.18u w=2.8u
M2 Y net93 VSS VSS N l=0.18u w=2.4u
M3 VDD net93 Y VDD P l=0.18u w=3.6u
M4 net91 C VSS VSS N l=0.18u w=0.72u
M5 VDD C net91 VDD P l=0.18u w=1.08u
M6 net60 B VSS VSS N l=0.18u w=1.7u
M7 VDD B net60 VDD P l=0.18u w=2.56u
M8 net62 A VSS VSS N l=0.18u w=2.4u
M9 VDD A net62 VDD P l=0.18u w=3.6u
M10 net87 net60 net62 VDD P l=0.18u w=3.52u
M11 net87 B net54 VDD P l=0.18u w=2.8u
M12 net93 net91 net99 VDD P l=0.18u w=2.8u
M13 net93 C net87 VDD P l=0.18u w=2.8u
M14 net99 B net62 VDD P l=0.18u w=3.46u
M15 net99 net60 net54 VDD P l=0.18u w=2.8u
M16 net87 B net62 VSS N l=0.18u w=2.4u
M17 net87 net60 net54 VSS N l=0.18u w=1.86u
M18 net93 C net99 VSS N l=0.18u w=1.86u
M19 net93 net91 net87 VSS N l=0.18u w=1.86u
M20 net99 net60 net62 VSS N l=0.18u w=2.4u
M21 net99 B net54 VSS N l=0.18u w=1.86u
.ends XNOR3X4
*.SCALE meter
.GLOBAL GND VSS VDD

.subckt XOR2X1 Y A B
M0 net29 net21 net37 VDD P l=0.18u w=0.72u
M1 net29 A net38 VDD P l=0.18u w=0.72u
M2 net29 A net37 VSS N l=0.18u w=0.48u
M3 net29 net21 net38 VSS N l=0.18u w=0.48u
M4 Y net29 VSS VSS N l=0.18u w=0.6u
M5 VDD net29 Y VDD P l=0.18u w=0.9u
M6 net21 A VSS VSS N l=0.18u w=0.3u
M7 VDD A net21 VDD P l=0.18u w=0.42u
M8 net37 net38 VSS VSS N l=0.18u w=0.48u
M9 VDD net38 net37 VDD P l=0.18u w=0.72u
M10 net38 B VSS VSS N l=0.18u w=1.2u
M11 VDD B net38 VDD P l=0.18u w=1.64u
.ends XOR2X1
*.SCALE meter
.GLOBAL GND VSS VDD

.subckt XOR2X2 Y A B
M0 net29 net21 net37 VDD P l=0.18u w=1.4u
M1 net29 A net38 VDD P l=0.18u w=1.4u
M2 net29 A net37 VSS N l=0.18u w=0.92u
M3 net29 net21 net38 VSS N l=0.18u w=0.92u
M4 Y net29 VSS VSS N l=0.18u w=1.2u
M5 VDD net29 Y VDD P l=0.18u w=1.76u
M6 net21 A VSS VSS N l=0.18u w=0.38u
M7 VDD A net21 VDD P l=0.18u w=0.56u
M8 net37 net38 VSS VSS N l=0.18u w=0.92u
M9 VDD net38 net37 VDD P l=0.18u w=1.4u
M10 net38 B VSS VSS N l=0.18u w=2.52u
M11 VDD B net38 VDD P l=0.18u w=3.82u
.ends XOR2X2
*.SCALE meter
.GLOBAL GND VSS VDD

.subckt XOR2X4 Y A B
M0 net29 net21 net37 VDD P l=0.18u w=2.84u
M1 net29 A net38 VDD P l=0.18u w=3u
M2 net29 A net37 VSS N l=0.18u w=2.18u
M3 net29 net21 net38 VSS N l=0.18u w=2.1u
M4 Y net29 VSS VSS N l=0.18u w=2.6u
M5 VDD net29 Y VDD P l=0.18u w=3.32u
M6 net21 A VSS VSS N l=0.18u w=0.76u
M7 VDD A net21 VDD P l=0.18u w=1.14u
M8 net37 net38 VSS VSS N l=0.18u w=1.9u
M9 VDD net38 net37 VDD P l=0.18u w=2.84u
M10 net38 B VSS VSS N l=0.18u w=5.04u
M11 VDD B net38 VDD P l=0.18u w=7.2u
.ends XOR2X4
*.SCALE meter
.GLOBAL GND VSS VDD

.subckt XOR2XL Y A B
M0 net29 net21 net37 VDD P l=0.18u w=0.84u
M1 net29 A net38 VDD P l=0.18u w=0.84u
M2 net29 A net37 VSS N l=0.18u w=0.56u
M3 net29 net21 net38 VSS N l=0.18u w=0.56u
M4 Y net29 VSS VSS N l=0.18u w=0.46u
M5 VDD net29 Y VDD P l=0.18u w=0.64u
M6 net21 A VSS VSS N l=0.18u w=0.3u
M7 VDD A net21 VDD P l=0.18u w=0.42u
M8 net37 net38 VSS VSS N l=0.18u w=0.3u
M9 VDD net38 net37 VDD P l=0.18u w=0.46u
M10 net38 B VSS VSS N l=0.18u w=0.3u
M11 VDD B net38 VDD P l=0.18u w=0.46u
.ends XOR2XL
*.SCALE meter
.GLOBAL GND VSS VDD

.subckt XOR3X2 Y A B C
M0 net53 net61 VSS VSS N l=0.18u w=0.93u
M1 VDD net61 net53 VDD P l=0.18u w=1.4u
M2 Y net92 VSS VSS N l=0.18u w=1.2u
M3 VDD net92 Y VDD P l=0.18u w=1.8u
M4 net72 C VSS VSS N l=0.18u w=0.36u
M5 VDD C net72 VDD P l=0.18u w=0.54u
M6 net59 B VSS VSS N l=0.18u w=0.85u
M7 VDD B net59 VDD P l=0.18u w=1.28u
M8 net61 A VSS VSS N l=0.18u w=1.2u
M9 VDD A net61 VDD P l=0.18u w=1.8u
M10 net86 net59 net61 VDD P l=0.18u w=1.76u
M11 net86 B net53 VDD P l=0.18u w=1.4u
M12 net92 C net98 VDD P l=0.18u w=1.4u
M13 net92 net72 net86 VDD P l=0.18u w=1.4u
M14 net98 B net61 VDD P l=0.18u w=1.76u
M15 net98 net59 net53 VDD P l=0.18u w=1.4u
M16 net86 B net61 VSS N l=0.18u w=1.2u
M17 net86 net59 net53 VSS N l=0.18u w=0.93u
M18 net92 net72 net98 VSS N l=0.18u w=0.93u
M19 net92 C net86 VSS N l=0.18u w=0.93u
M20 net98 net59 net61 VSS N l=0.18u w=1.2u
M21 net98 B net53 VSS N l=0.18u w=0.93u
.ends XOR3X2
*.SCALE meter
.GLOBAL GND VSS VDD

.subckt XOR3X4 Y A B C
M0 net53 net61 VSS VSS N l=0.18u w=1.86u
M1 VDD net61 net53 VDD P l=0.18u w=2.8u
M2 Y net92 VSS VSS N l=0.18u w=2.4u
M3 VDD net92 Y VDD P l=0.18u w=3.6u
M4 net72 C VSS VSS N l=0.18u w=0.72u
M5 VDD C net72 VDD P l=0.18u w=1.08u
M6 net59 B VSS VSS N l=0.18u w=1.7u
M7 VDD B net59 VDD P l=0.18u w=2.56u
M8 net61 A VSS VSS N l=0.18u w=2.4u
M9 VDD A net61 VDD P l=0.18u w=3.6u
M10 net86 net59 net61 VDD P l=0.18u w=3.52u
M11 net86 B net53 VDD P l=0.18u w=2.8u
M12 net92 C net98 VDD P l=0.18u w=2.8u
M13 net92 net72 net86 VDD P l=0.18u w=2.8u
M14 net98 B net61 VDD P l=0.18u w=3.46u
M15 net98 net59 net53 VDD P l=0.18u w=2.8u
M16 net86 B net61 VSS N l=0.18u w=2.4u
M17 net86 net59 net53 VSS N l=0.18u w=1.86u
M18 net92 net72 net98 VSS N l=0.18u w=1.86u
M19 net92 C net86 VSS N l=0.18u w=1.86u
M20 net98 net59 net61 VSS N l=0.18u w=2.4u
M21 net98 B net53 VSS N l=0.18u w=1.86u
.ends XOR3X4
